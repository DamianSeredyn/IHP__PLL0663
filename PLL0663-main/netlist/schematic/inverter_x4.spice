** sch_path: /foss/designs/IHP__PLL0663/PLL0663-main/schematic/xschem/divider/inverter_x4.sch
.subckt inverter_x4 IN OUT VP GND
*.PININFO IN:I VP:B OUT:O GND:B
MM1 OUT IN GND GND sg13_lv_nmos w=0.60u l=0.13u ng=1
MM2 OUT IN VP VP sg13_lv_pmos w=0.60u l=0.13u ng=1
.ends
