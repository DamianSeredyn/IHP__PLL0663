** sch_path: /foss/designs/IHP__PLL0663/PLL0663-main/schematic/xschem/vco/vco_core_4.sch
.subckt vco_core_4 vp gnd out in
*.PININFO in:I vp:B out:O gnd:B
MM1 pgt in gnd gnd sg13_lv_nmos w=0.8u l=5.9*4u ng=1
MM2 pgt pgt vp vp sg13_lv_pmos w=1.2u l=5.9*4u ng=1
x1 vp pgt out 1th in gnd vco_delay_cell_4
x2 vp pgt 1th 2th in gnd vco_delay_cell_4
x3 vp pgt 2th 3th in gnd vco_delay_cell_4
x4 vp pgt 3th 4th in gnd vco_delay_cell_4
x7 vp pgt 10th out in gnd vco_delay_cell_4
x8 vp pgt 4th 5th in gnd vco_delay_cell_4
x9 vp pgt 5th 6th in gnd vco_delay_cell_4
x10 vp pgt 6th 7th in gnd vco_delay_cell_4
x11 vp pgt 7th 8th in gnd vco_delay_cell_4
x12 vp pgt 8th 9th in gnd vco_delay_cell_4
x13 vp pgt 9th 10th in gnd vco_delay_cell_4
.ends

* expanding   symbol:  /foss/designs/IHP__PLL0663/PLL0663-main/schematic/xschem/vco/vco_delay_cell_4.sym # of pins=6
** sym_path: /foss/designs/IHP__PLL0663/PLL0663-main/schematic/xschem/vco/vco_delay_cell_4.sym
** sch_path: /foss/designs/IHP__PLL0663/PLL0663-main/schematic/xschem/vco/vco_delay_cell_4.sch
.subckt vco_delay_cell_4 vp pgt in out ngt gnd
*.PININFO in:I out:O gnd:B vp:B pgt:B ngt:B
MM23 up pgt vp vp sg13_lv_pmos w=1.2u l=5.9*4u ng=1
MM24 out in up vp sg13_lv_pmos w=1.2u l=5.9*2u ng=1
MM25 out in dn gnd sg13_lv_nmos w=0.8u l=5.9*2u ng=1
MM26 dn ngt gnd gnd sg13_lv_nmos w=0.8u l=5.9*4u ng=1
.ends
