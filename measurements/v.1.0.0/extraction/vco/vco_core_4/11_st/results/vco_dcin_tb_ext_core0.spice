** sch_path: /foss/designs/CHIP-PLL/schematics/vco/vco_tb/vco_dcin_tb.sch
**.subckt vco_dcin_tb
V1 in 0 {vin} ac 1
.save i(v1)
V2 vdd 0 {vdd}
x2 out in vdd 0 vco_core_0
V3 en5 0 0
*connector(1,1) ?1 en5
C3 out_pb 0 50f
x14 en5 nen5 vdd 0 inverter
*connector(1,1) ?1 nen5
x3 en5 en11 vdd 0 inverter
*connector(1,1) ?1 en11
x4 en11 nen11 vdd 0 inverter
*connector(1,1) ?1 nen11
*connector(1,1) ?1 nen5
*connector(1,1) ?1 en11
*connector(1,1) ?1 nen11
x1 vdd 0 out_pb out 0_buf
*connector(1,1) ?1 en5
**** begin user architecture code

.param temp=27
.param vdd=1.2
.param vin=0.4

.control

tran 40p 700n
write vco_tb.raw
set appendwrite
plot out
plot out_pb
.endc

 .lib cornerMOSlv.lib mos_tt

**** end user architecture code
**.ends

* expanding   symbol:  /foss/designs/CHIP-PLL/schematics/vco/vco_cell/vco_core_2.sym # of pins=8
** sym_path: /foss/designs/CHIP-PLL/schematics/vco/vco_cell/vco_core_2.sym
** sch_path: /foss/designs/CHIP-PLL/schematics/vco/vco_cell/vco_core_2.sch

* expanding   symbol:  /foss/designs/CHIP-PLL/schematics/divider/schematics/inverter.sym # of pins=4
** sym_path: /foss/designs/CHIP-PLL/schematics/divider/schematics/inverter.sym
** sch_path: /foss/designs/CHIP-PLL/schematics/divider/schematics/inverter.sch
.subckt inverter IN OUT VP GND
*.ipin IN
*.iopin VP
*.opin OUT
*.iopin GND
XM1 OUT IN GND GND sg13_lv_nmos w=0.15u l=0.13u ng=1 m=1 mm_ok=1
XM2 OUT IN VP VP sg13_lv_pmos w=0.15u l=0.13u ng=1 m=1 mm_ok=1
.ends

* expanding   symbol:  /foss/designs/CHIP-PLL/schematics/vco/vco_cell/0_buf.sym # of pins=4
** sym_path: /foss/designs/CHIP-PLL/schematics/vco/vco_cell/0_buf.sym
** sch_path: /foss/designs/CHIP-PLL/schematics/vco/vco_cell/0_buf.sch
.subckt 0_buf vp gnd out in
*.ipin in
*.opin out
*.iopin vp
*.iopin gnd
XM9 3th 2th vp vp sg13_lv_pmos w=2.5u l=0.13u ng=1 m=1 mm_ok=1
XM10 3th 2th gnd gnd sg13_lv_nmos w=2.5u l=0.13u ng=1 m=1 mm_ok=1
XM11 2th 1th vp vp sg13_lv_pmos w=2.4u l=0.13u ng=1 m=1 mm_ok=1
XM12 2th 1th gnd gnd sg13_lv_nmos w=1.2u l=0.13u ng=1 m=1 mm_ok=1
XM1 4th 3th vp vp sg13_lv_pmos w=5u l=0.13u ng=1 m=1 mm_ok=1
XM2 4th 3th gnd gnd sg13_lv_nmos w=5u l=0.13u ng=1 m=1 mm_ok=1
XM3 5th 4th vp vp sg13_lv_pmos w=10u l=0.13u ng=1 m=1 mm_ok=1
XM4 5th 4th gnd gnd sg13_lv_nmos w=10u l=0.13u ng=1 m=1 mm_ok=1
XM5 out 5th vp vp sg13_lv_pmos w=10u l=0.13u ng=1 m=2 mm_ok=1
XM6 out 5th gnd gnd sg13_lv_nmos w=10u l=0.13u ng=1 m=2 mm_ok=1
XM7 1th in gnd gnd sg13_lv_nmos w=0.8u l=0.13u ng=1 m=1 mm_ok=1
XM8 1th in vp vp sg13_lv_pmos w=1.5u l=0.13u ng=1 m=1 mm_ok=1
.ends

* expanding   symbol:  /foss/designs/CHIP-PLL/schematics/vco/vco_cell/vco_delay_cell_2.sym # of pins=6
** sym_path: /foss/designs/CHIP-PLL/schematics/vco/vco_cell/vco_delay_cell_2.sym
** sch_path: /foss/designs/CHIP-PLL/schematics/vco/vco_cell/vco_delay_cell_2.sch
.subckt vco_delay_cell_2 vp pgt in out ngt gnd
*.ipin in
*.opin out
*.iopin gnd
*.iopin vp
*.iopin pgt
*.iopin ngt
XM23 up pgt vp vp sg13_lv_pmos w=1.2u l=1.4*4u ng=1 m=1 mm_ok=1
XM24 out in up vp sg13_lv_pmos w=1.2u l=1.4*2u ng=1 m=1 mm_ok=1
XM25 out in dn gnd sg13_lv_nmos w=0.8u l=1.4*2u ng=1 m=1 mm_ok=1
XM26 dn ngt gnd gnd sg13_lv_nmos w=0.8u l=1.4*4u ng=1 m=1 mm_ok=1
.ends

* expanding   symbol:  /foss/designs/CHIP-PLL/schematics/divider/schematics/passgate.sym # of pins=6
** sym_path: /foss/designs/CHIP-PLL/schematics/divider/schematics/passgate.sym
** sch_path: /foss/designs/CHIP-PLL/schematics/divider/schematics/passgate.sch
.subckt passgate in_p vp gnd in_n A B
*.ipin in_n
*.ipin in_p
*.iopin vp
*.iopin gnd
*.iopin B
*.iopin A
XM4 B in_p A vp sg13_lv_pmos w=0.3u l=0.15u ng=1 m=1 mm_ok=1
XM5 B in_n A gnd sg13_lv_nmos w=0.3u l=0.15u ng=1 m=1 mm_ok=1
.ends

* ==== BEGIN PEX substitutions (generated by -ext) ====
* ---- PEX adapter dla vco_core_0 ----
*   porty schematu (zachowane): out in vp gnd
*   porty ekstrakcji (xpex):    out in vp gnd
*   zwarcia (brak w ext):       [] -> {'v2i_vp': 'vp'}
.subckt vco_core_0 out in vp gnd
xpex out in vp gnd vco_core_0__pex
.ends
* PEX produced on Tue Oct 20 02:06:07 PM CEST 2026 using /foss/tools/sak/sak-pex.sh with m=2 and s=1
* NGSPICE file created from vco_core_0.ext - technology: ihp-sg13g2

.subckt vco_core_0__pex out in vp gnd
X0 vco_delay_cell_0$1_1.out vco_delay_cell_0$1_1.in a_292_626# gnd sg13_lv_nmos ad=76f pd=0.78u as=0.136p ps=1.48u w=0.4u l=0.28u
X1 vco_delay_cell_0$1_1.pgt vco_delay_cell_0$1_1.pgt vp vp sg13_lv_pmos ad=0.114p pd=0.98u as=0.204p ps=1.88u w=0.6u l=0.56u
X2 a_904_626# in gnd gnd sg13_lv_nmos ad=76f pd=0.78u as=0.136p ps=1.48u w=0.4u l=0.56u
X3 a_938_n478# out vco_delay_cell_0$1_3.in gnd sg13_lv_nmos ad=0.136p pd=1.48u as=76f ps=0.78u w=0.4u l=0.28u
X4 a_292_1054# vco_delay_cell_0$1_1.pgt vp vp sg13_lv_pmos ad=0.114p pd=0.98u as=0.204p ps=1.88u w=0.6u l=0.56u
X5 a_n354_n478# vco_delay_cell_0$1_2.in vco_delay_cell_0$1_1.in gnd sg13_lv_nmos ad=0.136p pd=1.48u as=76f ps=0.78u w=0.4u l=0.28u
X6 a_n354_n946# vco_delay_cell_0$1_1.pgt vp vp sg13_lv_pmos ad=0.114p pd=0.98u as=0.204p ps=1.88u w=0.6u l=0.56u
X7 vp vco_delay_cell_0$1_1.pgt a_904_1054# vp sg13_lv_pmos ad=0.204p pd=1.88u as=0.114p ps=0.98u w=0.6u l=0.56u
X8 a_938_n478# in gnd gnd sg13_lv_nmos ad=76f pd=0.78u as=0.136p ps=1.48u w=0.4u l=0.56u
X9 a_258_n478# vco_delay_cell_0$1_3.in vco_delay_cell_0$1_2.in gnd sg13_lv_nmos ad=0.136p pd=1.48u as=76f ps=0.78u w=0.4u l=0.28u
X10 vco_delay_cell_0$1_1.in vco_delay_cell_0$1_2.in a_n354_n946# vp sg13_lv_pmos ad=0.114p pd=0.98u as=0.204p ps=1.88u w=0.6u l=0.28u
X11 a_258_n478# in gnd gnd sg13_lv_nmos ad=76f pd=0.78u as=0.136p ps=1.48u w=0.4u l=0.56u
X12 a_292_1054# vco_delay_cell_0$1_1.in vco_delay_cell_0$1_1.out vp sg13_lv_pmos ad=0.204p pd=1.88u as=0.114p ps=0.98u w=0.6u l=0.28u
X13 a_292_626# vco_delay_cell_0$1_1.in vco_delay_cell_0$1_1.out gnd sg13_lv_nmos ad=0.136p pd=1.48u as=76f ps=0.78u w=0.4u l=0.28u
X14 a_n354_n478# in gnd gnd sg13_lv_nmos ad=76f pd=0.78u as=0.136p ps=1.48u w=0.4u l=0.56u
X15 out vco_delay_cell_0$1_1.out a_904_626# gnd sg13_lv_nmos ad=76f pd=0.78u as=0.136p ps=1.48u w=0.4u l=0.28u
X16 vp vco_delay_cell_0$1_1.pgt a_938_n946# vp sg13_lv_pmos ad=0.204p pd=1.88u as=0.114p ps=0.98u w=0.6u l=0.56u
X17 gnd in a_938_n478# gnd sg13_lv_nmos ad=0.136p pd=1.48u as=76f ps=0.78u w=0.4u l=0.56u
X18 vco_delay_cell_0$1_1.in vco_delay_cell_0$1_2.in a_n354_n478# gnd sg13_lv_nmos ad=76f pd=0.78u as=0.136p ps=1.48u w=0.4u l=0.28u
X19 vco_delay_cell_0$1_3.in out a_938_n946# vp sg13_lv_pmos ad=0.114p pd=0.98u as=0.204p ps=1.88u w=0.6u l=0.28u
X20 vp vco_delay_cell_0$1_1.pgt a_n354_n946# vp sg13_lv_pmos ad=0.204p pd=1.88u as=0.114p ps=0.98u w=0.6u l=0.56u
X21 gnd in a_904_626# gnd sg13_lv_nmos ad=0.136p pd=1.48u as=76f ps=0.78u w=0.4u l=0.56u
X22 gnd in vco_delay_cell_0$1_1.pgt gnd sg13_lv_nmos ad=0.136p pd=1.48u as=76f ps=0.78u w=0.4u l=0.56u
X23 gnd in a_258_n478# gnd sg13_lv_nmos ad=0.136p pd=1.48u as=76f ps=0.78u w=0.4u l=0.56u
X24 vco_delay_cell_0$1_2.in vco_delay_cell_0$1_3.in a_258_n946# vp sg13_lv_pmos ad=0.114p pd=0.98u as=0.204p ps=1.88u w=0.6u l=0.28u
X25 a_938_n946# vco_delay_cell_0$1_1.pgt vp vp sg13_lv_pmos ad=0.114p pd=0.98u as=0.204p ps=1.88u w=0.6u l=0.56u
X26 out vco_delay_cell_0$1_1.out a_904_1054# vp sg13_lv_pmos ad=0.114p pd=0.98u as=0.204p ps=1.88u w=0.6u l=0.28u
X27 vp vco_delay_cell_0$1_1.pgt a_258_n946# vp sg13_lv_pmos ad=0.204p pd=1.88u as=0.114p ps=0.98u w=0.6u l=0.56u
X28 vp vco_delay_cell_0$1_1.pgt a_292_1054# vp sg13_lv_pmos ad=0.204p pd=1.88u as=0.114p ps=0.98u w=0.6u l=0.56u
X29 a_904_1054# vco_delay_cell_0$1_1.out out vp sg13_lv_pmos ad=0.204p pd=1.88u as=0.114p ps=0.98u w=0.6u l=0.28u
X30 vp vco_delay_cell_0$1_1.pgt vco_delay_cell_0$1_1.pgt vp sg13_lv_pmos ad=0.204p pd=1.88u as=0.114p ps=0.98u w=0.6u l=0.56u
X31 vco_delay_cell_0$1_3.in out a_938_n478# gnd sg13_lv_nmos ad=76f pd=0.78u as=0.136p ps=1.48u w=0.4u l=0.28u
X32 a_258_n946# vco_delay_cell_0$1_1.pgt vp vp sg13_lv_pmos ad=0.114p pd=0.98u as=0.204p ps=1.88u w=0.6u l=0.56u
X33 a_292_626# in gnd gnd sg13_lv_nmos ad=76f pd=0.78u as=0.136p ps=1.48u w=0.4u l=0.56u
X34 a_938_n946# out vco_delay_cell_0$1_3.in vp sg13_lv_pmos ad=0.204p pd=1.88u as=0.114p ps=0.98u w=0.6u l=0.28u
X35 gnd in a_292_626# gnd sg13_lv_nmos ad=0.136p pd=1.48u as=76f ps=0.78u w=0.4u l=0.56u
X36 a_904_1054# vco_delay_cell_0$1_1.pgt vp vp sg13_lv_pmos ad=0.114p pd=0.98u as=0.204p ps=1.88u w=0.6u l=0.56u
X37 vco_delay_cell_0$1_1.pgt in gnd gnd sg13_lv_nmos ad=76f pd=0.78u as=0.136p ps=1.48u w=0.4u l=0.56u
X38 vco_delay_cell_0$1_2.in vco_delay_cell_0$1_3.in a_258_n478# gnd sg13_lv_nmos ad=76f pd=0.78u as=0.136p ps=1.48u w=0.4u l=0.28u
X39 a_n354_n946# vco_delay_cell_0$1_2.in vco_delay_cell_0$1_1.in vp sg13_lv_pmos ad=0.204p pd=1.88u as=0.114p ps=0.98u w=0.6u l=0.28u
X40 vco_delay_cell_0$1_1.out vco_delay_cell_0$1_1.in a_292_1054# vp sg13_lv_pmos ad=0.114p pd=0.98u as=0.204p ps=1.88u w=0.6u l=0.28u
X41 a_258_n946# vco_delay_cell_0$1_3.in vco_delay_cell_0$1_2.in vp sg13_lv_pmos ad=0.204p pd=1.88u as=0.114p ps=0.98u w=0.6u l=0.28u
X42 a_904_626# vco_delay_cell_0$1_1.out out gnd sg13_lv_nmos ad=0.136p pd=1.48u as=76f ps=0.78u w=0.4u l=0.28u
X43 gnd in a_n354_n478# gnd sg13_lv_nmos ad=0.136p pd=1.48u as=76f ps=0.78u w=0.4u l=0.56u
C0 vco_delay_cell_0$1_1.out a_904_1054# 0.07542f
C1 a_n354_n478# vco_delay_cell_0$1_1.in 0.10496f
C2 in vco_delay_cell_0$1_1.in 0.12079f
C3 vco_delay_cell_0$1_1.pgt a_938_n946# 0.10924f
C4 a_938_n478# vco_delay_cell_0$1_3.in 0.09696f
C5 out vco_delay_cell_0$1_1.pgt 0.03798f
C6 a_292_626# vp 0.02249f
C7 vco_delay_cell_0$1_2.in vp 0.47935f
C8 vco_delay_cell_0$1_1.out vco_delay_cell_0$1_1.in 0.20266f
C9 vco_delay_cell_0$1_2.in a_n354_n478# 0.06293f
C10 out a_938_n946# 0.07463f
C11 a_292_626# in 0.11885f
C12 vco_delay_cell_0$1_2.in in 0.05347f
C13 vco_delay_cell_0$1_1.pgt vp 4.78975f
C14 vco_delay_cell_0$1_3.in a_258_n478# 0.06216f
C15 a_292_626# vco_delay_cell_0$1_1.out 0.09698f
C16 vco_delay_cell_0$1_1.pgt in 0.06231f
C17 vp a_938_n946# 0.14901f
C18 a_n354_n946# vco_delay_cell_0$1_1.in 0.10417f
C19 vco_delay_cell_0$1_3.in a_258_n946# 0.0745f
C20 out vp 0.45414f
C21 vco_delay_cell_0$1_1.pgt vco_delay_cell_0$1_1.out 0.04821f
C22 out in 0.12788f
C23 a_292_1054# a_904_1054# 0.01319f
C24 vco_delay_cell_0$1_2.in a_n354_n946# 0.07542f
C25 a_292_626# a_904_626# 0.01214f
C26 out vco_delay_cell_0$1_1.out 0.24993f
C27 vp in 0.34844f
C28 vco_delay_cell_0$1_2.in a_258_n478# 0.09698f
C29 a_292_1054# vco_delay_cell_0$1_1.in 0.07196f
C30 a_n354_n478# in 0.11575f
C31 a_938_n478# out 0.07132f
C32 vco_delay_cell_0$1_1.pgt a_n354_n946# 0.11748f
C33 vco_delay_cell_0$1_2.in a_258_n946# 0.10368f
C34 vp vco_delay_cell_0$1_1.out 0.48613f
C35 vco_delay_cell_0$1_1.out in 0.05347f
C36 vco_delay_cell_0$1_1.pgt a_258_n946# 0.1101f
C37 out a_904_626# 0.10481f
C38 a_938_n478# in 0.11813f
C39 a_938_n946# a_258_n946# 0.01089f
C40 vco_delay_cell_0$1_1.pgt a_292_1054# 0.11904f
C41 vp a_n354_n946# 0.14471f
C42 vco_delay_cell_0$1_2.in vco_delay_cell_0$1_3.in 0.22287f
C43 a_904_626# in 0.11618f
C44 vp a_258_n478# 0.02249f
C45 a_n354_n478# a_258_n478# 0.01214f
C46 in a_258_n478# 0.11843f
C47 vco_delay_cell_0$1_1.pgt a_904_1054# 0.10776f
C48 vp a_258_n946# 0.17092f
C49 a_292_626# vco_delay_cell_0$1_1.in 0.06088f
C50 vco_delay_cell_0$1_2.in vco_delay_cell_0$1_1.in 0.24906f
C51 vco_delay_cell_0$1_1.pgt vco_delay_cell_0$1_3.in 0.0492f
C52 a_904_626# vco_delay_cell_0$1_1.out 0.06293f
C53 a_938_n946# vco_delay_cell_0$1_3.in 0.10367f
C54 a_292_1054# vp 0.17405f
C55 out a_904_1054# 0.10362f
C56 vco_delay_cell_0$1_1.pgt vco_delay_cell_0$1_1.in 0.67767f
C57 out vco_delay_cell_0$1_3.in 0.20875f
C58 vp a_904_1054# 0.14466f
C59 a_292_1054# vco_delay_cell_0$1_1.out 0.10368f
C60 vp vco_delay_cell_0$1_3.in 0.50024f
C61 vco_delay_cell_0$1_2.in vco_delay_cell_0$1_1.pgt 0.05223f
C62 vco_delay_cell_0$1_3.in in 0.05479f
C63 a_n354_n946# a_258_n946# 0.01319f
C64 vp vco_delay_cell_0$1_1.in 0.61167f
C65 out gnd 0.01673f
C66 vp gnd 1.37037f
C67 a_938_n946# gnd 0.29534f
C68 a_258_n946# gnd 0.13515f
C69 a_n354_n946# gnd 0.32948f
C70 a_938_n478# gnd 0.62533f
C71 a_258_n478# gnd 0.59105f
C72 a_n354_n478# gnd 0.36576f
C73 a_904_626# gnd 2.65945f
C74 a_292_626# gnd 0.49565f
C75 a_904_1054# gnd 0.02902f
C76 a_292_1054# gnd 0.262f
.ends
* ==== END PEX substitutions ====
.end
