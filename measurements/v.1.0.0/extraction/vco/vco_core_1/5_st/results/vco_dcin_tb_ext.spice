** sch_path: /foss/designs/CHIP-PLL/schematics/vco/vco_tb/vco_dcin_tb.sch
**.subckt vco_dcin_tb
V1 in 0 {vin} ac 1
.save i(v1)
V2 vdd 0 {vdd}
x2 vdd 0 out en5 in nen11 nen5 en11 vco_core_1
V3 en5 0 1.2
*connector(1,1) ?1 en5
C3 out_pb 0 50f
x14 en5 nen5 vdd 0 inverter
*connector(1,1) ?1 nen5
x3 en5 en11 vdd 0 inverter
*connector(1,1) ?1 en11
x4 en11 nen11 vdd 0 inverter
*connector(1,1) ?1 nen11
*connector(1,1) ?1 nen5
*connector(1,1) ?1 en11
*connector(1,1) ?1 nen11
x1 vdd 0 out_pb out 0_buf
*connector(1,1) ?1 en5
**** begin user architecture code

.param temp=27
.param vdd=1.2
.param vin=0.4

.control

tran 40p 700n
write vco_tb.raw
set appendwrite
plot out
plot out_pb
.endc

 .lib cornerMOSlv.lib mos_tt

**** end user architecture code
**.ends

* expanding   symbol:  /foss/designs/CHIP-PLL/schematics/vco/vco_cell/vco_core_1.sym # of pins=8
** sym_path: /foss/designs/CHIP-PLL/schematics/vco/vco_cell/vco_core_1.sym
** sch_path: /foss/designs/CHIP-PLL/schematics/vco/vco_cell/vco_core_1.sch

* expanding   symbol:  /foss/designs/CHIP-PLL/schematics/divider/schematics/inverter.sym # of pins=4
** sym_path: /foss/designs/CHIP-PLL/schematics/divider/schematics/inverter.sym
** sch_path: /foss/designs/CHIP-PLL/schematics/divider/schematics/inverter.sch
.subckt inverter IN OUT VP GND
*.ipin IN
*.iopin VP
*.opin OUT
*.iopin GND
XM1 OUT IN GND GND sg13_lv_nmos w=0.15u l=0.13u ng=1 m=1 mm_ok=1
XM2 OUT IN VP VP sg13_lv_pmos w=0.15u l=0.13u ng=1 m=1 mm_ok=1
.ends

* expanding   symbol:  /foss/designs/CHIP-PLL/schematics/vco/vco_cell/0_buf.sym # of pins=4
** sym_path: /foss/designs/CHIP-PLL/schematics/vco/vco_cell/0_buf.sym
** sch_path: /foss/designs/CHIP-PLL/schematics/vco/vco_cell/0_buf.sch
.subckt 0_buf vp gnd out in
*.ipin in
*.opin out
*.iopin vp
*.iopin gnd
XM9 3th 2th vp vp sg13_lv_pmos w=2.5u l=0.13u ng=1 m=1 mm_ok=1
XM10 3th 2th gnd gnd sg13_lv_nmos w=2.5u l=0.13u ng=1 m=1 mm_ok=1
XM11 2th 1th vp vp sg13_lv_pmos w=2.4u l=0.13u ng=1 m=1 mm_ok=1
XM12 2th 1th gnd gnd sg13_lv_nmos w=1.2u l=0.13u ng=1 m=1 mm_ok=1
XM1 4th 3th vp vp sg13_lv_pmos w=5u l=0.13u ng=1 m=1 mm_ok=1
XM2 4th 3th gnd gnd sg13_lv_nmos w=5u l=0.13u ng=1 m=1 mm_ok=1
XM3 5th 4th vp vp sg13_lv_pmos w=10u l=0.13u ng=1 m=1 mm_ok=1
XM4 5th 4th gnd gnd sg13_lv_nmos w=10u l=0.13u ng=1 m=1 mm_ok=1
XM5 out 5th vp vp sg13_lv_pmos w=10u l=0.13u ng=1 m=2 mm_ok=1
XM6 out 5th gnd gnd sg13_lv_nmos w=10u l=0.13u ng=1 m=2 mm_ok=1
XM7 1th in gnd gnd sg13_lv_nmos w=0.8u l=0.13u ng=1 m=1 mm_ok=1
XM8 1th in vp vp sg13_lv_pmos w=1.5u l=0.13u ng=1 m=1 mm_ok=1
.ends

* expanding   symbol:  /foss/designs/CHIP-PLL/schematics/vco/vco_cell/vco_delay_cell_1.sym # of pins=6
** sym_path: /foss/designs/CHIP-PLL/schematics/vco/vco_cell/vco_delay_cell_1.sym
** sch_path: /foss/designs/CHIP-PLL/schematics/vco/vco_cell/vco_delay_cell_1.sch
.subckt vco_delay_cell_1 vp pgt in out ngt gnd
*.ipin in
*.opin out
*.iopin gnd
*.iopin vp
*.iopin pgt
*.iopin ngt
XM23 up pgt vp vp sg13_lv_pmos w=1.2u l=0.35*4u ng=1 m=1 mm_ok=1
XM24 out in up vp sg13_lv_pmos w=1.2u l=0.35*2u ng=1 m=1 mm_ok=1
XM25 out in dn gnd sg13_lv_nmos w=0.8u l=0.35*2u ng=1 m=1 mm_ok=1
XM26 dn ngt gnd gnd sg13_lv_nmos w=0.8u l=0.35*4u ng=1 m=1 mm_ok=1
.ends

* expanding   symbol:  /foss/designs/CHIP-PLL/schematics/divider/schematics/passgate.sym # of pins=6
** sym_path: /foss/designs/CHIP-PLL/schematics/divider/schematics/passgate.sym
** sch_path: /foss/designs/CHIP-PLL/schematics/divider/schematics/passgate.sch
.subckt passgate in_p vp gnd in_n A B
*.ipin in_n
*.ipin in_p
*.iopin vp
*.iopin gnd
*.iopin B
*.iopin A
XM4 B in_p A vp sg13_lv_pmos w=0.3u l=0.15u ng=1 m=1 mm_ok=1
XM5 B in_n A gnd sg13_lv_nmos w=0.3u l=0.15u ng=1 m=1 mm_ok=1
.ends

* ==== BEGIN PEX substitutions (generated by -ext) ====
* ---- PEX adapter dla vco_core_1 ----
*   porty schematu (zachowane): vp gnd out en5 in nen11 nen5 en11
*   porty ekstrakcji (xpex):    out in en5 nen5 en11 nen11 vp gnd
*   zwarcia (brak w ext):       [] -> {'v2i_vp': 'vp'}
.subckt vco_core_1 vp gnd out en5 in nen11 nen5 en11
xpex out in en5 nen5 en11 nen11 vp gnd vco_core_1__pex
.ends
* PEX produced on Mon Nov  9 02:16:32 PM CET 2026 using /foss/tools/sak/sak-pex.sh with m=2 and s=1
* NGSPICE file created from vco_core_1.ext - technology: ihp-sg13cmos5l

.subckt vco_core_1__pex out in en5 nen5 en11 nen11 vp gnd
X0 a_760_n1856# vco_delay_cell_1_0.pgt vp vp sg13_lv_pmos ad=0.114p pd=0.98u as=0.204p ps=1.88u w=0.6u l=1.4u
X1 vco_delay_cell_1_5.in nen11 vco_delay_cell_1_3.out vp sg13_lv_pmos ad=0.102p pd=1.28u as=0.102p ps=1.28u w=0.3u l=0.15u
X2 a_758_n1386# vco_delay_cell_1_8.out vco_delay_cell_1_7.out gnd sg13_lv_nmos ad=0.136p pd=1.48u as=76f ps=0.78u w=0.4u l=0.7u
X3 vco_delay_cell_1_6.out vco_delay_cell_1_10.out a_1916_208# vp sg13_lv_pmos ad=0.114p pd=0.98u as=0.204p ps=1.88u w=0.6u l=0.7u
X4 vp vco_delay_cell_1_0.pgt a_n2640_n1856# vp sg13_lv_pmos ad=0.204p pd=1.88u as=0.114p ps=0.98u w=0.6u l=1.4u
X5 vco_delay_cell_1_4.out vco_delay_cell_1_7.out a_1916_n1856# vp sg13_lv_pmos ad=0.114p pd=0.98u as=0.204p ps=1.88u w=0.6u l=0.7u
X6 a_1914_n1386# in gnd gnd sg13_lv_nmos ad=76f pd=0.78u as=0.136p ps=1.48u w=0.4u l=1.4u
X7 a_n396_n1856# vco_delay_cell_1_0.pgt vp vp sg13_lv_pmos ad=0.114p pd=0.98u as=0.204p ps=1.88u w=0.6u l=1.4u
X8 gnd in vco_delay_cell_1_0.pgt gnd sg13_lv_nmos ad=0.136p pd=1.48u as=76f ps=0.78u w=0.4u l=1.4u
X9 a_n1554_n222# in gnd gnd sg13_lv_nmos ad=76f pd=0.78u as=0.136p ps=1.48u w=0.4u l=1.4u
X10 vco_delay_cell_1_2.out vco_delay_cell_1_9.out a_n398_n222# gnd sg13_lv_nmos ad=76f pd=0.78u as=0.136p ps=1.48u w=0.4u l=0.7u
X11 a_n1552_208# out vco_delay_cell_1_9.out vp sg13_lv_pmos ad=0.204p pd=1.88u as=0.114p ps=0.98u w=0.6u l=0.7u
X12 a_n1552_n1856# vco_delay_cell_1_0.pgt vp vp sg13_lv_pmos ad=0.114p pd=0.98u as=0.204p ps=1.88u w=0.6u l=1.4u
X13 vp vco_delay_cell_1_0.pgt a_1916_208# vp sg13_lv_pmos ad=0.204p pd=1.88u as=0.114p ps=0.98u w=0.6u l=1.4u
X14 gnd in a_3002_n1386# gnd sg13_lv_nmos ad=0.136p pd=1.48u as=76f ps=0.78u w=0.4u l=1.4u
X15 a_n2642_n1386# vco_delay_cell_1_0.in vco_delay_cell_1_0.out gnd sg13_lv_nmos ad=0.136p pd=1.48u as=76f ps=0.78u w=0.4u l=0.7u
X16 vco_delay_cell_1_5.in en11 vco_delay_cell_1_3.out gnd sg13_lv_nmos ad=0.102p pd=1.28u as=0.102p ps=1.28u w=0.3u l=0.15u
X17 a_3478_n222# vco_delay_cell_1_5.in out gnd sg13_lv_nmos ad=0.136p pd=1.48u as=76f ps=0.78u w=0.4u l=0.7u
X18 a_n2640_n1856# vco_delay_cell_1_0.in vco_delay_cell_1_0.out vp sg13_lv_pmos ad=0.204p pd=1.88u as=0.114p ps=0.98u w=0.6u l=0.7u
X19 gnd in a_3478_n222# gnd sg13_lv_nmos ad=0.136p pd=1.48u as=76f ps=0.78u w=0.4u l=1.4u
X20 vco_delay_cell_1_5.in nen5 vco_delay_cell_1_6.out vp sg13_lv_pmos ad=0.102p pd=1.28u as=0.102p ps=1.28u w=0.3u l=0.15u
X21 out vco_delay_cell_1_5.in a_3478_n222# gnd sg13_lv_nmos ad=76f pd=0.78u as=0.136p ps=1.48u w=0.4u l=0.7u
X22 gnd in a_n398_n222# gnd sg13_lv_nmos ad=0.136p pd=1.48u as=76f ps=0.78u w=0.4u l=1.4u
X23 a_1916_208# vco_delay_cell_1_10.out vco_delay_cell_1_6.out vp sg13_lv_pmos ad=0.204p pd=1.88u as=0.114p ps=0.98u w=0.6u l=0.7u
X24 vco_delay_cell_1_4.out vco_delay_cell_1_7.out a_1914_n1386# gnd sg13_lv_nmos ad=76f pd=0.78u as=0.136p ps=1.48u w=0.4u l=0.7u
X25 vco_delay_cell_1_8.out vco_delay_cell_1_1.out a_n398_n1386# gnd sg13_lv_nmos ad=76f pd=0.78u as=0.136p ps=1.48u w=0.4u l=0.7u
X26 vco_delay_cell_1_8.out vco_delay_cell_1_1.out a_n396_n1856# vp sg13_lv_pmos ad=0.114p pd=0.98u as=0.204p ps=1.88u w=0.6u l=0.7u
X27 vp vco_delay_cell_1_0.pgt a_3004_n1856# vp sg13_lv_pmos ad=0.204p pd=1.88u as=0.114p ps=0.98u w=0.6u l=1.4u
X28 vco_delay_cell_1_6.out vco_delay_cell_1_10.out a_1914_n222# gnd sg13_lv_nmos ad=76f pd=0.78u as=0.136p ps=1.48u w=0.4u l=0.7u
X29 a_1916_208# vco_delay_cell_1_0.pgt vp vp sg13_lv_pmos ad=0.114p pd=0.98u as=0.204p ps=1.88u w=0.6u l=1.4u
X30 vco_delay_cell_1_9.out out a_n1552_208# vp sg13_lv_pmos ad=0.114p pd=0.98u as=0.204p ps=1.88u w=0.6u l=0.7u
X31 a_1914_n222# vco_delay_cell_1_10.out vco_delay_cell_1_6.out gnd sg13_lv_nmos ad=0.136p pd=1.48u as=76f ps=0.78u w=0.4u l=0.7u
X32 gnd in a_n2642_n1386# gnd sg13_lv_nmos ad=0.136p pd=1.48u as=76f ps=0.78u w=0.4u l=1.4u
X33 vp vco_delay_cell_1_0.pgt a_n1552_208# vp sg13_lv_pmos ad=0.204p pd=1.88u as=0.114p ps=0.98u w=0.6u l=1.4u
X34 vp vco_delay_cell_1_0.pgt a_n1552_n1856# vp sg13_lv_pmos ad=0.204p pd=1.88u as=0.114p ps=0.98u w=0.6u l=1.4u
X35 a_n398_n1386# in gnd gnd sg13_lv_nmos ad=76f pd=0.78u as=0.136p ps=1.48u w=0.4u l=1.4u
X36 gnd in a_1914_n222# gnd sg13_lv_nmos ad=0.136p pd=1.48u as=76f ps=0.78u w=0.4u l=1.4u
X37 a_n2642_n1386# in gnd gnd sg13_lv_nmos ad=76f pd=0.78u as=0.136p ps=1.48u w=0.4u l=1.4u
X38 a_n1554_n1386# in gnd gnd sg13_lv_nmos ad=76f pd=0.78u as=0.136p ps=1.48u w=0.4u l=1.4u
X39 a_n398_n222# vco_delay_cell_1_9.out vco_delay_cell_1_2.out gnd sg13_lv_nmos ad=0.136p pd=1.48u as=76f ps=0.78u w=0.4u l=0.7u
X40 a_n1552_208# vco_delay_cell_1_0.pgt vp vp sg13_lv_pmos ad=0.114p pd=0.98u as=0.204p ps=1.88u w=0.6u l=1.4u
X41 a_n1554_n1386# vco_delay_cell_1_0.out vco_delay_cell_1_1.out gnd sg13_lv_nmos ad=0.136p pd=1.48u as=76f ps=0.78u w=0.4u l=0.7u
X42 a_n1552_n1856# vco_delay_cell_1_0.out vco_delay_cell_1_1.out vp sg13_lv_pmos ad=0.204p pd=1.88u as=0.114p ps=0.98u w=0.6u l=0.7u
X43 a_3004_n1856# vco_delay_cell_1_4.out vco_delay_cell_1_3.out vp sg13_lv_pmos ad=0.204p pd=1.88u as=0.114p ps=0.98u w=0.6u l=0.7u
X44 a_n398_n1386# vco_delay_cell_1_1.out vco_delay_cell_1_8.out gnd sg13_lv_nmos ad=0.136p pd=1.48u as=76f ps=0.78u w=0.4u l=0.7u
X45 a_n396_n1856# vco_delay_cell_1_1.out vco_delay_cell_1_8.out vp sg13_lv_pmos ad=0.204p pd=1.88u as=0.114p ps=0.98u w=0.6u l=0.7u
X46 vp vco_delay_cell_1_0.pgt a_n396_208# vp sg13_lv_pmos ad=0.204p pd=1.88u as=0.114p ps=0.98u w=0.6u l=1.4u
X47 out vco_delay_cell_1_5.in a_3480_208# vp sg13_lv_pmos ad=0.114p pd=0.98u as=0.204p ps=1.88u w=0.6u l=0.7u
X48 vco_delay_cell_1_10.out vco_delay_cell_1_2.out a_760_208# vp sg13_lv_pmos ad=0.114p pd=0.98u as=0.204p ps=1.88u w=0.6u l=0.7u
X49 vco_delay_cell_1_7.out vco_delay_cell_1_8.out a_760_n1856# vp sg13_lv_pmos ad=0.114p pd=0.98u as=0.204p ps=1.88u w=0.6u l=0.7u
X50 vp vco_delay_cell_1_0.pgt a_1916_n1856# vp sg13_lv_pmos ad=0.204p pd=1.88u as=0.114p ps=0.98u w=0.6u l=1.4u
X51 vp vco_delay_cell_1_0.pgt a_n396_n1856# vp sg13_lv_pmos ad=0.204p pd=1.88u as=0.114p ps=0.98u w=0.6u l=1.4u
X52 vco_delay_cell_1_5.in en5 vco_delay_cell_1_6.out gnd sg13_lv_nmos ad=0.102p pd=1.28u as=0.102p ps=1.28u w=0.3u l=0.15u
X53 a_3004_n1856# vco_delay_cell_1_0.pgt vp vp sg13_lv_pmos ad=0.114p pd=0.98u as=0.204p ps=1.88u w=0.6u l=1.4u
X54 vp vco_delay_cell_1_0.pgt a_760_n1856# vp sg13_lv_pmos ad=0.204p pd=1.88u as=0.114p ps=0.98u w=0.6u l=1.4u
X55 vp vco_delay_cell_1_0.pgt a_3480_208# vp sg13_lv_pmos ad=0.204p pd=1.88u as=0.114p ps=0.98u w=0.6u l=1.4u
X56 gnd in a_n1554_n1386# gnd sg13_lv_nmos ad=0.136p pd=1.48u as=76f ps=0.78u w=0.4u l=1.4u
X57 vco_delay_cell_1_0.pgt in gnd gnd sg13_lv_nmos ad=76f pd=0.78u as=0.136p ps=1.48u w=0.4u l=1.4u
X58 a_3002_n1386# vco_delay_cell_1_4.out vco_delay_cell_1_3.out gnd sg13_lv_nmos ad=0.136p pd=1.48u as=76f ps=0.78u w=0.4u l=0.7u
X59 a_758_n222# vco_delay_cell_1_2.out vco_delay_cell_1_10.out gnd sg13_lv_nmos ad=0.136p pd=1.48u as=76f ps=0.78u w=0.4u l=0.7u
X60 vp vco_delay_cell_1_0.pgt a_760_208# vp sg13_lv_pmos ad=0.204p pd=1.88u as=0.114p ps=0.98u w=0.6u l=1.4u
X61 vco_delay_cell_1_3.out vco_delay_cell_1_4.out a_3004_n1856# vp sg13_lv_pmos ad=0.114p pd=0.98u as=0.204p ps=1.88u w=0.6u l=0.7u
X62 a_3480_208# vco_delay_cell_1_5.in out vp sg13_lv_pmos ad=0.204p pd=1.88u as=0.114p ps=0.98u w=0.6u l=0.7u
X63 a_n396_208# vco_delay_cell_1_9.out vco_delay_cell_1_2.out vp sg13_lv_pmos ad=0.204p pd=1.88u as=0.114p ps=0.98u w=0.6u l=0.7u
X64 vco_delay_cell_1_0.in en11 vco_delay_cell_1_6.out gnd sg13_lv_nmos ad=0.102p pd=1.28u as=0.102p ps=1.28u w=0.3u l=0.15u
X65 a_3480_208# vco_delay_cell_1_0.pgt vp vp sg13_lv_pmos ad=0.114p pd=0.98u as=0.204p ps=1.88u w=0.6u l=1.4u
X66 a_760_208# vco_delay_cell_1_0.pgt vp vp sg13_lv_pmos ad=0.114p pd=0.98u as=0.204p ps=1.88u w=0.6u l=1.4u
X67 gnd in a_758_n222# gnd sg13_lv_nmos ad=0.136p pd=1.48u as=76f ps=0.78u w=0.4u l=1.4u
X68 vco_delay_cell_1_0.out vco_delay_cell_1_0.in a_n2642_n1386# gnd sg13_lv_nmos ad=76f pd=0.78u as=0.136p ps=1.48u w=0.4u l=0.7u
X69 vco_delay_cell_1_0.out vco_delay_cell_1_0.in a_n2640_n1856# vp sg13_lv_pmos ad=0.114p pd=0.98u as=0.204p ps=1.88u w=0.6u l=0.7u
X70 vco_delay_cell_1_7.out vco_delay_cell_1_8.out a_758_n1386# gnd sg13_lv_nmos ad=76f pd=0.78u as=0.136p ps=1.48u w=0.4u l=0.7u
X71 vco_delay_cell_1_9.out out a_n1554_n222# gnd sg13_lv_nmos ad=76f pd=0.78u as=0.136p ps=1.48u w=0.4u l=0.7u
X72 a_758_n222# in gnd gnd sg13_lv_nmos ad=76f pd=0.78u as=0.136p ps=1.48u w=0.4u l=1.4u
X73 a_n398_n222# in gnd gnd sg13_lv_nmos ad=76f pd=0.78u as=0.136p ps=1.48u w=0.4u l=1.4u
X74 vco_delay_cell_1_10.out vco_delay_cell_1_2.out a_758_n222# gnd sg13_lv_nmos ad=76f pd=0.78u as=0.136p ps=1.48u w=0.4u l=0.7u
X75 a_1914_n222# in gnd gnd sg13_lv_nmos ad=76f pd=0.78u as=0.136p ps=1.48u w=0.4u l=1.4u
X76 gnd in a_1914_n1386# gnd sg13_lv_nmos ad=0.136p pd=1.48u as=76f ps=0.78u w=0.4u l=1.4u
X77 a_n1554_n222# out vco_delay_cell_1_9.out gnd sg13_lv_nmos ad=0.136p pd=1.48u as=76f ps=0.78u w=0.4u l=0.7u
X78 a_760_208# vco_delay_cell_1_2.out vco_delay_cell_1_10.out vp sg13_lv_pmos ad=0.204p pd=1.88u as=0.114p ps=0.98u w=0.6u l=0.7u
X79 a_n2640_n1856# vco_delay_cell_1_0.pgt vp vp sg13_lv_pmos ad=0.114p pd=0.98u as=0.204p ps=1.88u w=0.6u l=1.4u
X80 a_n396_208# vco_delay_cell_1_0.pgt vp vp sg13_lv_pmos ad=0.114p pd=0.98u as=0.204p ps=1.88u w=0.6u l=1.4u
X81 a_3002_n1386# in gnd gnd sg13_lv_nmos ad=76f pd=0.78u as=0.136p ps=1.48u w=0.4u l=1.4u
X82 gnd in a_758_n1386# gnd sg13_lv_nmos ad=0.136p pd=1.48u as=76f ps=0.78u w=0.4u l=1.4u
X83 vco_delay_cell_1_0.pgt vco_delay_cell_1_0.pgt vp vp sg13_lv_pmos ad=0.114p pd=0.98u as=0.204p ps=1.88u w=0.6u l=1.4u
X84 a_1916_n1856# vco_delay_cell_1_7.out vco_delay_cell_1_4.out vp sg13_lv_pmos ad=0.204p pd=1.88u as=0.114p ps=0.98u w=0.6u l=0.7u
X85 a_1916_n1856# vco_delay_cell_1_0.pgt vp vp sg13_lv_pmos ad=0.114p pd=0.98u as=0.204p ps=1.88u w=0.6u l=1.4u
X86 gnd in a_n1554_n222# gnd sg13_lv_nmos ad=0.136p pd=1.48u as=76f ps=0.78u w=0.4u l=1.4u
X87 a_760_n1856# vco_delay_cell_1_8.out vco_delay_cell_1_7.out vp sg13_lv_pmos ad=0.204p pd=1.88u as=0.114p ps=0.98u w=0.6u l=0.7u
X88 gnd in a_n398_n1386# gnd sg13_lv_nmos ad=0.136p pd=1.48u as=76f ps=0.78u w=0.4u l=1.4u
X89 vco_delay_cell_1_3.out vco_delay_cell_1_4.out a_3002_n1386# gnd sg13_lv_nmos ad=76f pd=0.78u as=0.136p ps=1.48u w=0.4u l=0.7u
X90 vco_delay_cell_1_2.out vco_delay_cell_1_9.out a_n396_208# vp sg13_lv_pmos ad=0.114p pd=0.98u as=0.204p ps=1.88u w=0.6u l=0.7u
X91 a_1914_n1386# vco_delay_cell_1_7.out vco_delay_cell_1_4.out gnd sg13_lv_nmos ad=0.136p pd=1.48u as=76f ps=0.78u w=0.4u l=0.7u
X92 a_758_n1386# in gnd gnd sg13_lv_nmos ad=76f pd=0.78u as=0.136p ps=1.48u w=0.4u l=1.4u
X93 vco_delay_cell_1_0.in nen11 vco_delay_cell_1_6.out vp sg13_lv_pmos ad=0.102p pd=1.28u as=0.102p ps=1.28u w=0.3u l=0.15u
X94 vp vco_delay_cell_1_0.pgt vco_delay_cell_1_0.pgt vp sg13_lv_pmos ad=0.204p pd=1.88u as=0.114p ps=0.98u w=0.6u l=1.4u
X95 a_3478_n222# in gnd gnd sg13_lv_nmos ad=76f pd=0.78u as=0.136p ps=1.48u w=0.4u l=1.4u
X96 vco_delay_cell_1_1.out vco_delay_cell_1_0.out a_n1552_n1856# vp sg13_lv_pmos ad=0.114p pd=0.98u as=0.204p ps=1.88u w=0.6u l=0.7u
X97 vco_delay_cell_1_1.out vco_delay_cell_1_0.out a_n1554_n1386# gnd sg13_lv_nmos ad=76f pd=0.78u as=0.136p ps=1.48u w=0.4u l=0.7u
C0 vp a_760_n1856# 0.17137f
C1 vco_delay_cell_1_4.out in 0.10131f
C2 a_760_208# vp 0.17137f
C3 vco_delay_cell_1_9.out vp 0.76781f
C4 a_1914_n222# vco_delay_cell_1_10.out 0.0826f
C5 vco_delay_cell_1_5.in vco_delay_cell_1_6.out 0.22477f
C6 nen11 vco_delay_cell_1_3.out 0.0715f
C7 vco_delay_cell_1_0.pgt a_760_n1856# 0.19842f
C8 vco_delay_cell_1_0.out a_n2642_n1386# 0.08217f
C9 vp a_3004_n1856# 0.16462f
C10 vco_delay_cell_1_0.out a_n1554_n1386# 0.08429f
C11 vco_delay_cell_1_9.out a_n396_208# 0.10901f
C12 vco_delay_cell_1_0.pgt a_760_208# 0.18377f
C13 a_n1552_n1856# vp 0.19055f
C14 vco_delay_cell_1_1.out a_n1554_n1386# 0.08216f
C15 vco_delay_cell_1_0.pgt vco_delay_cell_1_9.out 0.21112f
C16 out vco_delay_cell_1_5.in 0.43332f
C17 a_n396_n1856# vp 0.17222f
C18 vco_delay_cell_1_0.pgt a_3004_n1856# 0.17441f
C19 a_n1552_n1856# vco_delay_cell_1_0.pgt 0.19314f
C20 vco_delay_cell_1_0.pgt a_n396_n1856# 0.19792f
C21 a_n2642_n1386# vco_delay_cell_1_0.in 0.10123f
C22 en11 nen11 0.22183f
C23 vco_delay_cell_1_5.in vco_delay_cell_1_0.in 0.01051f
C24 a_758_n222# in 0.18219f
C25 a_758_n222# vco_delay_cell_1_2.out 0.0826f
C26 vco_delay_cell_1_6.out vco_delay_cell_1_10.out 0.31541f
C27 vco_delay_cell_1_7.out vco_delay_cell_1_4.out 0.32178f
C28 vco_delay_cell_1_0.pgt a_n398_n1386# 0.02882f
C29 vco_delay_cell_1_7.out a_1916_n1856# 0.11019f
C30 out vco_delay_cell_1_10.out 0.17865f
C31 vco_delay_cell_1_5.in a_3478_n222# 0.16528f
C32 en11 in 0.52058f
C33 a_3002_n1386# vco_delay_cell_1_4.out 0.08414f
C34 vco_delay_cell_1_0.pgt a_758_n1386# 0.02985f
C35 vco_delay_cell_1_0.in vco_delay_cell_1_10.out 0.17071f
C36 nen5 nen11 0.02254f
C37 a_n398_n222# vco_delay_cell_1_0.in 0.06454f
C38 a_n1554_n1386# vp 0.02393f
C39 vp vco_delay_cell_1_5.in 0.70354f
C40 vco_delay_cell_1_0.pgt a_1914_n1386# 0.01803f
C41 nen11 a_1916_208# 0.02441f
C42 vco_delay_cell_1_0.pgt a_n2642_n1386# 0.01095f
C43 vco_delay_cell_1_0.pgt a_n1554_n1386# 0.02435f
C44 nen11 in 0.11357f
C45 vco_delay_cell_1_0.pgt vco_delay_cell_1_5.in 0.09905f
C46 en5 en11 0.0231f
C47 a_3002_n1386# vco_delay_cell_1_3.out 0.08852f
C48 in vco_delay_cell_1_2.out 0.03774f
C49 en11 vco_delay_cell_1_6.out 0.02048f
C50 vp vco_delay_cell_1_10.out 0.615f
C51 a_758_n222# vco_delay_cell_1_0.in 0.06455f
C52 en11 a_3002_n1386# 0.07206f
C53 vco_delay_cell_1_0.pgt vco_delay_cell_1_10.out 0.2113f
C54 a_1914_n222# in 0.18203f
C55 vp vco_delay_cell_1_4.out 0.62675f
C56 vco_delay_cell_1_0.pgt a_n398_n222# 0.02221f
C57 vco_delay_cell_1_8.out in 0.12892f
C58 vp a_1916_n1856# 0.17009f
C59 vco_delay_cell_1_7.out nen11 0.02053f
C60 vco_delay_cell_1_0.pgt vco_delay_cell_1_4.out 0.22046f
C61 en11 vco_delay_cell_1_0.in 0.10379f
C62 a_760_208# vco_delay_cell_1_10.out 0.08272f
C63 nen11 vco_delay_cell_1_6.out 0.18557f
C64 vco_delay_cell_1_0.pgt a_1916_n1856# 0.18522f
C65 en5 in 0.0198f
C66 vco_delay_cell_1_9.out a_n398_n222# 0.0826f
C67 vco_delay_cell_1_7.out in 0.12893f
C68 out nen11 0.06634f
C69 vp vco_delay_cell_1_3.out 0.21606f
C70 out nen5 0.0165f
C71 vco_delay_cell_1_6.out a_1916_208# 0.0827f
C72 a_n1554_n222# in 0.18219f
C73 vco_delay_cell_1_4.out a_3004_n1856# 0.11032f
C74 vco_delay_cell_1_6.out in 0.01889f
C75 vco_delay_cell_1_0.pgt vco_delay_cell_1_3.out 0.03008f
C76 out a_1916_208# 0.06771f
C77 vco_delay_cell_1_0.out in 0.12564f
C78 nen11 vco_delay_cell_1_0.in 0.04239f
C79 vco_delay_cell_1_1.out in 0.12892f
C80 out in 0.04251f
C81 vco_delay_cell_1_0.pgt a_758_n222# 0.02264f
C82 a_3002_n1386# in 0.18108f
C83 out vco_delay_cell_1_2.out 0.17911f
C84 vco_delay_cell_1_8.out vco_delay_cell_1_7.out 0.32016f
C85 en11 vp 0.03129f
C86 a_n2640_n1856# vco_delay_cell_1_0.out 0.09177f
C87 a_1914_n222# vco_delay_cell_1_6.out 0.09024f
C88 vco_delay_cell_1_3.out a_3004_n1856# 0.10186f
C89 vco_delay_cell_1_0.in in 1.22357f
C90 vco_delay_cell_1_0.pgt en11 0.27796f
C91 vco_delay_cell_1_0.in vco_delay_cell_1_2.out 0.17f
C92 vco_delay_cell_1_1.out vco_delay_cell_1_8.out 0.32016f
C93 a_n2640_n1856# vco_delay_cell_1_0.in 0.11189f
C94 a_3480_208# out 0.15209f
C95 in a_3478_n222# 0.17996f
C96 a_1914_n222# vco_delay_cell_1_0.in 0.06387f
C97 vp nen11 0.78779f
C98 nen5 vp 0.15082f
C99 out a_n1552_208# 0.18762f
C100 vco_delay_cell_1_0.pgt nen11 0.81673f
C101 vco_delay_cell_1_4.out a_1914_n1386# 0.08217f
C102 out a_n1554_n222# 0.08207f
C103 out vco_delay_cell_1_6.out 0.14856f
C104 vp a_1916_208# 0.15959f
C105 vp in 0.48239f
C106 vco_delay_cell_1_0.out vco_delay_cell_1_1.out 0.32125f
C107 vp vco_delay_cell_1_2.out 0.62262f
C108 vco_delay_cell_1_0.pgt a_1916_208# 0.17313f
C109 a_n396_208# vco_delay_cell_1_2.out 0.08272f
C110 vco_delay_cell_1_0.pgt in 1.70042f
C111 a_n1554_n222# vco_delay_cell_1_0.in 0.06482f
C112 a_n2640_n1856# vp 0.16146f
C113 vco_delay_cell_1_0.pgt vco_delay_cell_1_2.out 0.23467f
C114 vco_delay_cell_1_0.in vco_delay_cell_1_6.out 0.43098f
C115 nen11 a_3004_n1856# 0.04147f
C116 vco_delay_cell_1_0.out vco_delay_cell_1_0.in 0.35866f
C117 a_n2640_n1856# vco_delay_cell_1_0.pgt 0.1812f
C118 out vco_delay_cell_1_0.in 0.04273f
C119 vco_delay_cell_1_5.in vco_delay_cell_1_3.out 0.27933f
C120 vco_delay_cell_1_8.out vp 0.64705f
C121 a_760_208# vco_delay_cell_1_2.out 0.10901f
C122 vco_delay_cell_1_0.pgt a_1914_n222# 0.01252f
C123 vco_delay_cell_1_9.out in 0.03774f
C124 vco_delay_cell_1_9.out vco_delay_cell_1_2.out 0.32016f
C125 a_3480_208# vp 0.15864f
C126 vco_delay_cell_1_0.pgt vco_delay_cell_1_8.out 0.33104f
C127 out a_3478_n222# 0.07551f
C128 vco_delay_cell_1_7.out vp 0.64568f
C129 vco_delay_cell_1_0.pgt a_3480_208# 0.16242f
C130 vco_delay_cell_1_8.out a_760_n1856# 0.11019f
C131 en11 vco_delay_cell_1_5.in 0.08691f
C132 vco_delay_cell_1_4.out a_1916_n1856# 0.09177f
C133 a_n1552_208# vp 0.18946f
C134 a_n1554_n222# vp 0.01949f
C135 vp vco_delay_cell_1_6.out 0.22432f
C136 vco_delay_cell_1_0.pgt vco_delay_cell_1_7.out 0.30616f
C137 vco_delay_cell_1_0.pgt a_n1552_208# 0.18657f
C138 a_n398_n1386# in 0.1911f
C139 vco_delay_cell_1_0.out vp 0.689f
C140 vco_delay_cell_1_0.pgt a_n1554_n222# 0.02587f
C141 vco_delay_cell_1_1.out vp 0.82275f
C142 out vp 1.26954f
C143 vco_delay_cell_1_0.pgt vco_delay_cell_1_6.out 0.11339f
C144 a_n396_n1856# vco_delay_cell_1_8.out 0.09176f
C145 a_758_n222# vco_delay_cell_1_10.out 0.07362f
C146 vco_delay_cell_1_7.out a_760_n1856# 0.09176f
C147 vco_delay_cell_1_3.out vco_delay_cell_1_4.out 0.31196f
C148 out a_n396_208# 0.06802f
C149 vco_delay_cell_1_0.pgt vco_delay_cell_1_0.out 0.27187f
C150 vco_delay_cell_1_0.pgt vco_delay_cell_1_1.out 0.30631f
C151 vco_delay_cell_1_0.pgt out 1.55401f
C152 vco_delay_cell_1_0.pgt a_3002_n1386# 0.01718f
C153 vco_delay_cell_1_9.out a_n1552_208# 0.08272f
C154 a_758_n1386# in 0.1911f
C155 vco_delay_cell_1_5.in nen11 0.06265f
C156 vp vco_delay_cell_1_0.in 0.66512f
C157 a_n1554_n222# vco_delay_cell_1_9.out 0.07362f
C158 vco_delay_cell_1_8.out a_n398_n1386# 0.08216f
C159 out a_760_208# 0.06797f
C160 vco_delay_cell_1_0.pgt vco_delay_cell_1_0.in 0.59556f
C161 out vco_delay_cell_1_9.out 0.50725f
C162 in a_1914_n1386# 0.19114f
C163 a_n2642_n1386# in 0.19123f
C164 en11 vco_delay_cell_1_4.out 0.04415f
C165 a_n1554_n1386# in 0.19114f
C166 a_n1552_n1856# vco_delay_cell_1_0.out 0.11032f
C167 vco_delay_cell_1_5.in in 0.2264f
C168 a_n1552_n1856# vco_delay_cell_1_1.out 0.09176f
C169 a_n396_n1856# vco_delay_cell_1_1.out 0.11019f
C170 vco_delay_cell_1_8.out a_758_n1386# 0.08419f
C171 vco_delay_cell_1_9.out vco_delay_cell_1_0.in 0.17f
C172 nen11 vco_delay_cell_1_10.out 0.02615f
C173 en11 vco_delay_cell_1_3.out 0.09264f
C174 vco_delay_cell_1_1.out a_n398_n1386# 0.08419f
C175 vco_delay_cell_1_7.out a_758_n1386# 0.08216f
C176 nen11 vco_delay_cell_1_4.out 0.09952f
C177 a_n396_208# vp 0.17204f
C178 a_1916_208# vco_delay_cell_1_10.out 0.10901f
C179 vco_delay_cell_1_0.pgt vp 17.5155f
C180 in vco_delay_cell_1_10.out 0.03774f
C181 a_3480_208# vco_delay_cell_1_5.in 0.1136f
C182 vco_delay_cell_1_10.out vco_delay_cell_1_2.out 0.32016f
C183 a_n398_n222# in 0.18219f
C184 vco_delay_cell_1_7.out a_1914_n1386# 0.08419f
C185 vco_delay_cell_1_0.pgt a_n396_208# 0.18326f
C186 a_n398_n222# vco_delay_cell_1_2.out 0.07362f
C187 vp gnd 3.56242f
C188 a_3004_n1856# gnd 0.41334f
C189 a_1916_n1856# gnd 0.47902f
C190 a_760_n1856# gnd 2.21097f
C191 a_n2640_n1856# gnd 0.026f
C192 vco_delay_cell_1_3.out gnd 1.58147f
C193 a_3002_n1386# gnd 0.21954f
C194 a_1914_n1386# gnd 7.27937f
C195 a_758_n1386# gnd 0.3988f
C196 a_n398_n1386# gnd 0.6505f
C197 a_n1554_n1386# gnd 0.66581f
C198 a_n2642_n1386# gnd 0.68671f
C199 a_3478_n222# gnd 1.15924f
C200 a_1914_n222# gnd 0.15263f
C201 a_758_n222# gnd 0.16284f
C202 a_n398_n222# gnd 0.77387f
C203 a_n1554_n222# gnd 0.18535f
C204 vco_delay_cell_1_6.out gnd 0.57553f
C205 vco_delay_cell_1_10.out gnd 0.53227f
C206 a_3480_208# gnd 0.06211f
C207 a_1916_208# gnd 0.22899f
C208 a_760_208# gnd 0.53576f
C209 a_n396_208# gnd 0.0134f
C210 a_n1552_208# gnd 0.75801f
.ends
* ==== END PEX substitutions ====
.end
