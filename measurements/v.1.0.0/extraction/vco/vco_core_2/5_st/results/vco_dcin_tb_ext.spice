** sch_path: /foss/designs/CHIP-PLL/schematics/vco/vco_tb/vco_dcin_tb.sch
**.subckt vco_dcin_tb
V1 in 0 {vin} ac 1
.save i(v1)
V2 vdd 0 {vdd}
x2 vdd 0 out in en5 nen5 nen11 en11 vco_core_2
V3 en5 0 1.2
*connector(1,1) ?1 en5
C3 out_pb 0 50f
x14 en5 nen5 vdd 0 inverter
*connector(1,1) ?1 nen5
x3 en5 en11 vdd 0 inverter
*connector(1,1) ?1 en11
x4 en11 nen11 vdd 0 inverter
*connector(1,1) ?1 nen11
*connector(1,1) ?1 nen5
*connector(1,1) ?1 en11
*connector(1,1) ?1 nen11
x1 vdd 0 out_pb out 0_buf
*connector(1,1) ?1 en5
**** begin user architecture code

.param temp=27
.param vdd=1.2
.param vin=0.4

.control

tran 40p 700n
write vco_tb.raw
set appendwrite
plot out
plot out_pb
.endc

 .lib cornerMOSlv.lib mos_tt

**** end user architecture code
**.ends

* expanding   symbol:  /foss/designs/CHIP-PLL/schematics/vco/vco_cell/vco_core_2.sym # of pins=8
** sym_path: /foss/designs/CHIP-PLL/schematics/vco/vco_cell/vco_core_2.sym
** sch_path: /foss/designs/CHIP-PLL/schematics/vco/vco_cell/vco_core_2.sch

* expanding   symbol:  /foss/designs/CHIP-PLL/schematics/divider/schematics/inverter.sym # of pins=4
** sym_path: /foss/designs/CHIP-PLL/schematics/divider/schematics/inverter.sym
** sch_path: /foss/designs/CHIP-PLL/schematics/divider/schematics/inverter.sch
.subckt inverter IN OUT VP GND
*.ipin IN
*.iopin VP
*.opin OUT
*.iopin GND
XM1 OUT IN GND GND sg13_lv_nmos w=0.15u l=0.13u ng=1 m=1 mm_ok=1
XM2 OUT IN VP VP sg13_lv_pmos w=0.15u l=0.13u ng=1 m=1 mm_ok=1
.ends

* expanding   symbol:  /foss/designs/CHIP-PLL/schematics/vco/vco_cell/0_buf.sym # of pins=4
** sym_path: /foss/designs/CHIP-PLL/schematics/vco/vco_cell/0_buf.sym
** sch_path: /foss/designs/CHIP-PLL/schematics/vco/vco_cell/0_buf.sch
.subckt 0_buf vp gnd out in
*.ipin in
*.opin out
*.iopin vp
*.iopin gnd
XM9 3th 2th vp vp sg13_lv_pmos w=2.5u l=0.13u ng=1 m=1 mm_ok=1
XM10 3th 2th gnd gnd sg13_lv_nmos w=2.5u l=0.13u ng=1 m=1 mm_ok=1
XM11 2th 1th vp vp sg13_lv_pmos w=2.4u l=0.13u ng=1 m=1 mm_ok=1
XM12 2th 1th gnd gnd sg13_lv_nmos w=1.2u l=0.13u ng=1 m=1 mm_ok=1
XM1 4th 3th vp vp sg13_lv_pmos w=5u l=0.13u ng=1 m=1 mm_ok=1
XM2 4th 3th gnd gnd sg13_lv_nmos w=5u l=0.13u ng=1 m=1 mm_ok=1
XM3 5th 4th vp vp sg13_lv_pmos w=10u l=0.13u ng=1 m=1 mm_ok=1
XM4 5th 4th gnd gnd sg13_lv_nmos w=10u l=0.13u ng=1 m=1 mm_ok=1
XM5 out 5th vp vp sg13_lv_pmos w=10u l=0.13u ng=1 m=2 mm_ok=1
XM6 out 5th gnd gnd sg13_lv_nmos w=10u l=0.13u ng=1 m=2 mm_ok=1
XM7 1th in gnd gnd sg13_lv_nmos w=0.8u l=0.13u ng=1 m=1 mm_ok=1
XM8 1th in vp vp sg13_lv_pmos w=1.5u l=0.13u ng=1 m=1 mm_ok=1
.ends

* expanding   symbol:  /foss/designs/CHIP-PLL/schematics/vco/vco_cell/vco_delay_cell_2.sym # of pins=6
** sym_path: /foss/designs/CHIP-PLL/schematics/vco/vco_cell/vco_delay_cell_2.sym
** sch_path: /foss/designs/CHIP-PLL/schematics/vco/vco_cell/vco_delay_cell_2.sch
.subckt vco_delay_cell_2 vp pgt in out ngt gnd
*.ipin in
*.opin out
*.iopin gnd
*.iopin vp
*.iopin pgt
*.iopin ngt
XM23 up pgt vp vp sg13_lv_pmos w=1.2u l=1.4*4u ng=1 m=1 mm_ok=1
XM24 out in up vp sg13_lv_pmos w=1.2u l=1.4*2u ng=1 m=1 mm_ok=1
XM25 out in dn gnd sg13_lv_nmos w=0.8u l=1.4*2u ng=1 m=1 mm_ok=1
XM26 dn ngt gnd gnd sg13_lv_nmos w=0.8u l=1.4*4u ng=1 m=1 mm_ok=1
.ends

* expanding   symbol:  /foss/designs/CHIP-PLL/schematics/divider/schematics/passgate.sym # of pins=6
** sym_path: /foss/designs/CHIP-PLL/schematics/divider/schematics/passgate.sym
** sch_path: /foss/designs/CHIP-PLL/schematics/divider/schematics/passgate.sch
.subckt passgate in_p vp gnd in_n A B
*.ipin in_n
*.ipin in_p
*.iopin vp
*.iopin gnd
*.iopin B
*.iopin A
XM4 B in_p A vp sg13_lv_pmos w=0.3u l=0.15u ng=1 m=1 mm_ok=1
XM5 B in_n A gnd sg13_lv_nmos w=0.3u l=0.15u ng=1 m=1 mm_ok=1
.ends

* ==== BEGIN PEX substitutions (generated by -ext) ====
* ---- PEX adapter dla vco_core_2 ----
*   porty schematu (zachowane): vp gnd out in en5 nen5 nen11 en11
*   porty ekstrakcji (xpex):    out in vp gnd nen11 en11 nen5 en5
*   zwarcia (brak w ext):       [] -> {'v2i_vp': 'vp'}
.subckt vco_core_2 vp gnd out in en5 nen5 nen11 en11
xpex out in vp gnd nen11 en11 nen5 en5 vco_core_2__pex
.ends
* PEX produced on Mon Nov  9 02:16:36 PM CET 2026 using /foss/tools/sak/sak-pex.sh with m=2 and s=1
* NGSPICE file created from vco_core_2.ext - technology: ihp-sg13cmos5l

.subckt vco_core_2__pex out in vp gnd nen11 en11 nen5 en5
X0 vco_delay_cell_2_4.in en11 vco_delay_cell_2_0.out gnd sg13_lv_nmos ad=0.102p pd=1.28u as=0.102p ps=1.28u w=0.3u l=0.15u
X1 vco_delay_cell_2_7.out vco_delay_cell_2_8.out a_842_n3122# vp sg13_lv_pmos ad=0.408p pd=3.08u as=0.408p ps=3.08u w=1.2u l=2.8u
X2 vco_delay_cell_2_9.out vco_delay_cell_2_7.out a_2270_n1580# gnd sg13_lv_nmos ad=0.272p pd=2.28u as=0.272p ps=2.28u w=0.8u l=2.8u
X3 vco_delay_cell_2_3.out vco_delay_cell_2_1.out a_3698_674# vp sg13_lv_pmos ad=0.408p pd=3.08u as=0.408p ps=3.08u w=1.2u l=2.8u
X4 gnd in a_n586_n788# gnd sg13_lv_nmos ad=0.272p pd=2.28u as=0.272p ps=2.28u w=0.8u l=5.6u
X5 gnd in a_5602_n788# gnd sg13_lv_nmos ad=0.272p pd=2.28u as=0.272p ps=2.28u w=0.8u l=5.6u
X6 vco_delay_cell_2_9.out vco_delay_cell_2_7.out a_2270_n3122# vp sg13_lv_pmos ad=0.408p pd=3.08u as=0.408p ps=3.08u w=1.2u l=2.8u
X7 out vco_delay_cell_2_4.in a_5602_n788# gnd sg13_lv_nmos ad=0.272p pd=2.28u as=0.272p ps=2.28u w=0.8u l=2.8u
X8 gnd in a_5126_n1580# gnd sg13_lv_nmos ad=0.272p pd=2.28u as=0.272p ps=2.28u w=0.8u l=5.6u
X9 vp vco_delay_cell_2_5.pgt a_5126_n3122# vp sg13_lv_pmos ad=0.408p pd=3.08u as=0.408p ps=3.08u w=1.2u l=5.6u
X10 vco_delay_cell_2_6.in nen11 vco_delay_cell_2_3.out vp sg13_lv_pmos ad=0.102p pd=1.28u as=0.102p ps=1.28u w=0.3u l=0.15u
X11 vco_delay_cell_2_3.out vco_delay_cell_2_1.out a_3698_n788# gnd sg13_lv_nmos ad=0.272p pd=2.28u as=0.272p ps=2.28u w=0.8u l=2.8u
X12 vco_delay_cell_2_2.out vco_delay_cell_2_5.out a_842_674# vp sg13_lv_pmos ad=0.408p pd=3.08u as=0.408p ps=3.08u w=1.2u l=2.8u
X13 vco_delay_cell_2_5.pgt vco_delay_cell_2_5.pgt vp vp sg13_lv_pmos ad=0.408p pd=3.08u as=0.408p ps=3.08u w=1.2u l=5.6u
X14 vco_delay_cell_2_2.out vco_delay_cell_2_5.out a_842_n788# gnd sg13_lv_nmos ad=0.272p pd=2.28u as=0.272p ps=2.28u w=0.8u l=2.8u
X15 gnd in a_2270_n788# gnd sg13_lv_nmos ad=0.272p pd=2.28u as=0.272p ps=2.28u w=0.8u l=5.6u
X16 gnd in a_2270_n1580# gnd sg13_lv_nmos ad=0.272p pd=2.28u as=0.272p ps=2.28u w=0.8u l=5.6u
X17 vp vco_delay_cell_2_5.pgt a_2270_n3122# vp sg13_lv_pmos ad=0.408p pd=3.08u as=0.408p ps=3.08u w=1.2u l=5.6u
X18 vco_delay_cell_2_1.out vco_delay_cell_2_2.out a_2270_n788# gnd sg13_lv_nmos ad=0.272p pd=2.28u as=0.272p ps=2.28u w=0.8u l=2.8u
X19 vp vco_delay_cell_2_5.pgt a_842_674# vp sg13_lv_pmos ad=0.408p pd=3.08u as=0.408p ps=3.08u w=1.2u l=5.6u
X20 vp vco_delay_cell_2_5.pgt a_3698_674# vp sg13_lv_pmos ad=0.408p pd=3.08u as=0.408p ps=3.08u w=1.2u l=5.6u
X21 vco_delay_cell_2_5.out out a_n586_n788# gnd sg13_lv_nmos ad=0.272p pd=2.28u as=0.272p ps=2.28u w=0.8u l=2.8u
X22 vco_delay_cell_2_8.out vco_delay_cell_2_6.out a_n586_n1580# gnd sg13_lv_nmos ad=0.272p pd=2.28u as=0.272p ps=2.28u w=0.8u l=2.8u
X23 vco_delay_cell_2_8.out vco_delay_cell_2_6.out a_n586_n3122# vp sg13_lv_pmos ad=0.408p pd=3.08u as=0.408p ps=3.08u w=1.2u l=2.8u
X24 vco_delay_cell_2_0.in vco_delay_cell_2_9.out a_3698_n1580# gnd sg13_lv_nmos ad=0.272p pd=2.28u as=0.272p ps=2.28u w=0.8u l=2.8u
X25 vco_delay_cell_2_4.in en5 vco_delay_cell_2_3.out gnd sg13_lv_nmos ad=0.102p pd=1.28u as=0.102p ps=1.28u w=0.3u l=0.15u
X26 vco_delay_cell_2_0.in vco_delay_cell_2_9.out a_3698_n3122# vp sg13_lv_pmos ad=0.408p pd=3.08u as=0.408p ps=3.08u w=1.2u l=2.8u
X27 gnd in a_n2014_n1580# gnd sg13_lv_nmos ad=0.272p pd=2.28u as=0.272p ps=2.28u w=0.8u l=5.6u
X28 vp vco_delay_cell_2_5.pgt a_n2014_n3122# vp sg13_lv_pmos ad=0.408p pd=3.08u as=0.408p ps=3.08u w=1.2u l=5.6u
X29 vco_delay_cell_2_5.out out a_n586_674# vp sg13_lv_pmos ad=0.408p pd=3.08u as=0.408p ps=3.08u w=1.2u l=2.8u
X30 vco_delay_cell_2_4.in nen11 vco_delay_cell_2_0.out vp sg13_lv_pmos ad=0.102p pd=1.28u as=0.102p ps=1.28u w=0.3u l=0.15u
X31 vco_delay_cell_2_4.in nen5 vco_delay_cell_2_3.out vp sg13_lv_pmos ad=0.102p pd=1.28u as=0.102p ps=1.28u w=0.3u l=0.15u
X32 gnd in a_842_n1580# gnd sg13_lv_nmos ad=0.272p pd=2.28u as=0.272p ps=2.28u w=0.8u l=5.6u
X33 vp vco_delay_cell_2_5.pgt a_842_n3122# vp sg13_lv_pmos ad=0.408p pd=3.08u as=0.408p ps=3.08u w=1.2u l=5.6u
X34 gnd in a_3698_n1580# gnd sg13_lv_nmos ad=0.272p pd=2.28u as=0.272p ps=2.28u w=0.8u l=5.6u
X35 vp vco_delay_cell_2_5.pgt a_3698_n3122# vp sg13_lv_pmos ad=0.408p pd=3.08u as=0.408p ps=3.08u w=1.2u l=5.6u
X36 vp vco_delay_cell_2_5.pgt a_5602_674# vp sg13_lv_pmos ad=0.408p pd=3.08u as=0.408p ps=3.08u w=1.2u l=5.6u
X37 vp vco_delay_cell_2_5.pgt a_n586_674# vp sg13_lv_pmos ad=0.408p pd=3.08u as=0.408p ps=3.08u w=1.2u l=5.6u
X38 gnd in a_3698_n788# gnd sg13_lv_nmos ad=0.272p pd=2.28u as=0.272p ps=2.28u w=0.8u l=5.6u
X39 out vco_delay_cell_2_4.in a_5602_674# vp sg13_lv_pmos ad=0.408p pd=3.08u as=0.408p ps=3.08u w=1.2u l=2.8u
X40 vp vco_delay_cell_2_5.pgt a_2270_674# vp sg13_lv_pmos ad=0.408p pd=3.08u as=0.408p ps=3.08u w=1.2u l=5.6u
X41 vco_delay_cell_2_1.out vco_delay_cell_2_2.out a_2270_674# vp sg13_lv_pmos ad=0.408p pd=3.08u as=0.408p ps=3.08u w=1.2u l=2.8u
X42 vco_delay_cell_2_5.pgt in gnd gnd sg13_lv_nmos ad=0.272p pd=2.28u as=0.272p ps=2.28u w=0.8u l=5.6u
X43 vco_delay_cell_2_6.in en11 vco_delay_cell_2_3.out gnd sg13_lv_nmos ad=0.102p pd=1.28u as=0.102p ps=1.28u w=0.3u l=0.15u
X44 vco_delay_cell_2_6.out vco_delay_cell_2_6.in a_n2014_n1580# gnd sg13_lv_nmos ad=0.272p pd=2.28u as=0.272p ps=2.28u w=0.8u l=2.8u
X45 vco_delay_cell_2_0.out vco_delay_cell_2_0.in a_5126_n1580# gnd sg13_lv_nmos ad=0.272p pd=2.28u as=0.272p ps=2.28u w=0.8u l=2.8u
X46 gnd in a_n586_n1580# gnd sg13_lv_nmos ad=0.272p pd=2.28u as=0.272p ps=2.28u w=0.8u l=5.6u
X47 vco_delay_cell_2_6.out vco_delay_cell_2_6.in a_n2014_n3122# vp sg13_lv_pmos ad=0.408p pd=3.08u as=0.408p ps=3.08u w=1.2u l=2.8u
X48 vco_delay_cell_2_0.out vco_delay_cell_2_0.in a_5126_n3122# vp sg13_lv_pmos ad=0.408p pd=3.08u as=0.408p ps=3.08u w=1.2u l=2.8u
X49 vp vco_delay_cell_2_5.pgt a_n586_n3122# vp sg13_lv_pmos ad=0.408p pd=3.08u as=0.408p ps=3.08u w=1.2u l=5.6u
X50 gnd in a_842_n788# gnd sg13_lv_nmos ad=0.272p pd=2.28u as=0.272p ps=2.28u w=0.8u l=5.6u
X51 vco_delay_cell_2_7.out vco_delay_cell_2_8.out a_842_n1580# gnd sg13_lv_nmos ad=0.272p pd=2.28u as=0.272p ps=2.28u w=0.8u l=2.8u
C0 vco_delay_cell_2_3.out en11 0.01419f
C1 a_842_n788# in 0.09937f
C2 vco_delay_cell_2_3.out vp 0.4656f
C3 nen5 a_5602_674# 0.08406f
C4 a_3698_n1580# vco_delay_cell_2_9.out 0.04828f
C5 vco_delay_cell_2_3.out nen11 0.06453f
C6 vp a_2270_n788# 0.01349f
C7 vco_delay_cell_2_5.pgt vco_delay_cell_2_6.in 0.53162f
C8 vco_delay_cell_2_5.pgt vco_delay_cell_2_9.out 0.33586f
C9 in en11 0.59236f
C10 vp in 0.80756f
C11 vco_delay_cell_2_2.out a_842_674# 0.01099f
C12 vco_delay_cell_2_4.in a_5602_n788# 0.12477f
C13 nen11 in 0.17583f
C14 vco_delay_cell_2_1.out a_2270_674# 0.01099f
C15 a_5602_674# vco_delay_cell_2_4.in 0.07505f
C16 a_3698_n3122# vp 0.25431f
C17 out a_5602_674# 0.0729f
C18 vco_delay_cell_2_5.pgt a_5126_n3122# 0.11866f
C19 vp a_3698_n788# 0.01349f
C20 vco_delay_cell_2_7.out vco_delay_cell_2_9.out 0.24685f
C21 vp a_5602_n788# 0.01897f
C22 vco_delay_cell_2_6.in vco_delay_cell_2_1.out 0.15327f
C23 vco_delay_cell_2_6.in a_n2014_n1580# 0.04888f
C24 vco_delay_cell_2_5.pgt vco_delay_cell_2_8.out 0.41308f
C25 vp a_5602_674# 0.21754f
C26 vco_delay_cell_2_5.pgt vco_delay_cell_2_2.out 0.34557f
C27 in vco_delay_cell_2_0.in 0.17588f
C28 vco_delay_cell_2_6.in vco_delay_cell_2_5.out 0.15104f
C29 vco_delay_cell_2_5.pgt a_842_n3122# 0.13127f
C30 out a_2270_674# 0.07194f
C31 vco_delay_cell_2_8.out vco_delay_cell_2_7.out 0.25051f
C32 a_3698_n3122# vco_delay_cell_2_0.in 0.01099f
C33 vco_delay_cell_2_7.out a_2270_n1580# 0.04828f
C34 vp a_2270_674# 0.25433f
C35 vco_delay_cell_2_6.in out 0.11924f
C36 a_842_n3122# vco_delay_cell_2_7.out 0.01099f
C37 vco_delay_cell_2_2.out vco_delay_cell_2_1.out 0.24686f
C38 vco_delay_cell_2_6.in a_n586_n788# 0.06365f
C39 vco_delay_cell_2_6.in a_842_n788# 0.06582f
C40 vco_delay_cell_2_3.out in 0.01678f
C41 a_2270_n788# in 0.09464f
C42 vco_delay_cell_2_5.pgt a_n586_n3122# 0.1292f
C43 vp vco_delay_cell_2_6.out 1.27297f
C44 vco_delay_cell_2_6.in en11 0.06608f
C45 vco_delay_cell_2_3.out a_3698_n788# 0.01064f
C46 a_n2014_n3122# vco_delay_cell_2_6.out 0.01099f
C47 vco_delay_cell_2_6.in vp 1.51978f
C48 vp vco_delay_cell_2_9.out 1.26545f
C49 vco_delay_cell_2_6.in nen11 0.03362f
C50 vco_delay_cell_2_2.out vco_delay_cell_2_5.out 0.24862f
C51 nen11 vco_delay_cell_2_9.out 0.0237f
C52 vco_delay_cell_2_6.in a_n2014_n3122# 0.05618f
C53 a_3698_n788# in 0.09464f
C54 vco_delay_cell_2_5.pgt a_842_674# 0.12538f
C55 a_5126_n3122# vp 0.25697f
C56 a_5126_n3122# nen11 0.04805f
C57 in a_5602_n788# 0.08945f
C58 vp a_n586_n1580# 0.01364f
C59 vco_delay_cell_2_2.out out 0.13724f
C60 nen5 en5 0.09523f
C61 vco_delay_cell_2_0.out vco_delay_cell_2_4.in 0.25874f
C62 vp vco_delay_cell_2_8.out 1.26735f
C63 vco_delay_cell_2_0.in vco_delay_cell_2_9.out 0.24685f
C64 vp vco_delay_cell_2_2.out 1.2456f
C65 vco_delay_cell_2_5.pgt a_3698_n1580# 0.01094f
C66 a_2270_n3122# vco_delay_cell_2_9.out 0.01099f
C67 en5 vco_delay_cell_2_4.in 0.24232f
C68 vp a_842_n1580# 0.01344f
C69 out en5 0.01426f
C70 vp a_2270_n1580# 0.01344f
C71 vp a_842_n3122# 0.25431f
C72 vco_delay_cell_2_0.out en11 0.04471f
C73 vp vco_delay_cell_2_0.out 0.46045f
C74 vco_delay_cell_2_5.pgt a_n586_674# 0.16679f
C75 nen11 vco_delay_cell_2_0.out 0.04706f
C76 a_5126_n3122# vco_delay_cell_2_0.in 0.06561f
C77 en5 en11 0.05473f
C78 vco_delay_cell_2_5.out a_842_674# 0.0643f
C79 vp en5 0.13111f
C80 vco_delay_cell_2_5.pgt vco_delay_cell_2_7.out 0.44003f
C81 nen11 en5 0.0177f
C82 vco_delay_cell_2_6.in vco_delay_cell_2_3.out 0.55724f
C83 vco_delay_cell_2_5.pgt a_3698_674# 0.12745f
C84 vco_delay_cell_2_6.in a_2270_n788# 0.06582f
C85 in vco_delay_cell_2_6.out 0.22849f
C86 vco_delay_cell_2_6.in in 1.80911f
C87 vco_delay_cell_2_5.pgt vco_delay_cell_2_1.out 0.25081f
C88 in vco_delay_cell_2_9.out 0.24029f
C89 vp a_n586_n3122# 0.25588f
C90 out a_842_674# 0.07213f
C91 a_3698_n3122# vco_delay_cell_2_9.out 0.06587f
C92 vco_delay_cell_2_6.in a_3698_n788# 0.066f
C93 vco_delay_cell_2_0.out vco_delay_cell_2_0.in 0.24859f
C94 vco_delay_cell_2_5.pgt vco_delay_cell_2_5.out 0.32883f
C95 vco_delay_cell_2_5.pgt nen5 0.38637f
C96 vco_delay_cell_2_1.out a_3698_674# 0.06429f
C97 in a_n586_n1580# 0.09881f
C98 vp a_842_674# 0.25433f
C99 vco_delay_cell_2_2.out a_2270_n788# 0.04729f
C100 vco_delay_cell_2_8.out in 0.22946f
C101 vco_delay_cell_2_5.pgt vco_delay_cell_2_4.in 0.10426f
C102 vco_delay_cell_2_5.pgt out 1.56585f
C103 vco_delay_cell_2_2.out in 0.14151f
C104 vco_delay_cell_2_5.pgt a_n586_n788# 0.03615f
C105 a_n586_674# out 0.0714f
C106 a_842_n1580# in 0.1032f
C107 a_2270_n1580# in 0.09881f
C108 vp a_3698_n1580# 0.01344f
C109 vco_delay_cell_2_3.out en5 0.02076f
C110 vco_delay_cell_2_5.pgt vp 30.5951f
C111 vco_delay_cell_2_5.pgt nen11 0.25376f
C112 vco_delay_cell_2_5.pgt a_n2014_n3122# 0.1276f
C113 out a_3698_674# 0.07189f
C114 vp a_n586_674# 0.22283f
C115 en5 in 0.86104f
C116 vco_delay_cell_2_1.out out 0.13676f
C117 a_5126_n1580# en11 0.03819f
C118 vp a_5126_n1580# 0.01539f
C119 nen11 a_5126_n1580# 0.01237f
C120 vco_delay_cell_2_6.in vco_delay_cell_2_6.out 0.25203f
C121 vp vco_delay_cell_2_7.out 1.26727f
C122 vp a_3698_674# 0.2537f
C123 en5 a_5602_n788# 0.05251f
C124 vp vco_delay_cell_2_1.out 1.23654f
C125 out vco_delay_cell_2_5.out 0.39357f
C126 vp a_n2014_n1580# 0.0453f
C127 nen11 vco_delay_cell_2_1.out 0.02347f
C128 nen5 out 0.34433f
C129 a_842_n788# vco_delay_cell_2_5.out 0.04733f
C130 vco_delay_cell_2_5.pgt vco_delay_cell_2_0.in 0.14232f
C131 a_n586_n1580# vco_delay_cell_2_6.out 0.04828f
C132 vco_delay_cell_2_5.pgt a_2270_n3122# 0.12971f
C133 vco_delay_cell_2_2.out a_2270_674# 0.06429f
C134 vp vco_delay_cell_2_5.out 1.22133f
C135 vp nen5 0.40112f
C136 out vco_delay_cell_2_4.in 0.3576f
C137 nen11 nen5 0.14247f
C138 vco_delay_cell_2_8.out vco_delay_cell_2_6.out 0.25158f
C139 a_5126_n1580# vco_delay_cell_2_0.in 0.04828f
C140 a_n586_n788# out 0.0411f
C141 vco_delay_cell_2_7.out a_2270_n3122# 0.06587f
C142 vco_delay_cell_2_6.in vco_delay_cell_2_2.out 0.15149f
C143 vco_delay_cell_2_4.in en11 0.06846f
C144 vp vco_delay_cell_2_4.in 1.82754f
C145 vco_delay_cell_2_5.pgt vco_delay_cell_2_3.out 0.01056f
C146 nen11 vco_delay_cell_2_4.in 0.10371f
C147 vp out 2.07326f
C148 nen11 out 0.16518f
C149 vp a_n586_n788# 0.01409f
C150 vp a_842_n788# 0.01349f
C151 a_3698_n1580# in 0.09881f
C152 vco_delay_cell_2_5.pgt in 1.3314f
C153 vp en11 0.13619f
C154 vco_delay_cell_2_5.pgt a_3698_n3122# 0.1342f
C155 nen11 en11 0.51142f
C156 vp nen11 1.3557f
C157 vco_delay_cell_2_3.out a_3698_674# 0.01169f
C158 vp a_n2014_n3122# 0.28432f
C159 a_5126_n1580# in 0.09584f
C160 a_5126_n3122# vco_delay_cell_2_0.out 0.01099f
C161 vco_delay_cell_2_7.out in 0.2389f
C162 vco_delay_cell_2_3.out vco_delay_cell_2_1.out 0.25055f
C163 a_n586_n3122# vco_delay_cell_2_6.out 0.06587f
C164 vco_delay_cell_2_5.pgt a_5602_674# 0.11225f
C165 a_842_n1580# vco_delay_cell_2_8.out 0.04828f
C166 vco_delay_cell_2_1.out in 0.14367f
C167 vco_delay_cell_2_8.out a_842_n3122# 0.06587f
C168 a_n2014_n1580# in 0.09004f
C169 vco_delay_cell_2_1.out a_3698_n788# 0.04731f
C170 vco_delay_cell_2_0.in en11 0.08753f
C171 vp vco_delay_cell_2_0.in 1.3131f
C172 in vco_delay_cell_2_5.out 0.13235f
C173 nen11 vco_delay_cell_2_0.in 0.20011f
C174 vp a_2270_n3122# 0.25431f
C175 vco_delay_cell_2_3.out vco_delay_cell_2_4.in 0.36084f
C176 vco_delay_cell_2_3.out out 0.06536f
C177 vco_delay_cell_2_8.out a_n586_n3122# 0.01099f
C178 vco_delay_cell_2_5.pgt a_2270_674# 0.12389f
C179 in vco_delay_cell_2_4.in 0.24433f
C180 out in 0.13426f
C181 a_n586_n788# in 0.09249f
C182 vco_delay_cell_2_5.pgt vco_delay_cell_2_6.out 0.38507f
C183 out gnd 0.35623f
C184 vp gnd 5.20705f
C185 a_5126_n3122# gnd 2.74926f
C186 a_842_n3122# gnd 0.42576f
C187 a_n2014_n3122# gnd 0.03618f
C188 vco_delay_cell_2_0.out gnd 1.63058f
C189 vco_delay_cell_2_7.out gnd 0.21676f
C190 vco_delay_cell_2_6.out gnd 1.127f
C191 a_5126_n1580# gnd 0.96368f
C192 a_3698_n1580# gnd 0.9102f
C193 a_2270_n1580# gnd 0.80604f
C194 a_842_n1580# gnd 0.39412f
C195 a_n586_n1580# gnd 0.61088f
C196 a_n2014_n1580# gnd 1.32102f
C197 a_5602_n788# gnd 1.14548f
C198 a_3698_n788# gnd 0.17659f
C199 a_2270_n788# gnd 0.79583f
C200 a_842_n788# gnd 0.17731f
C201 a_n586_n788# gnd 12.90158f
C202 vco_delay_cell_2_3.out gnd 2.14168f
C203 vco_delay_cell_2_1.out gnd 0.61851f
C204 vco_delay_cell_2_5.out gnd 0.95665f
C205 a_5602_674# gnd 0.36881f
C206 a_3698_674# gnd 0.41517f
C207 a_842_674# gnd 0.42335f
.ends
* ==== END PEX substitutions ====
.end
