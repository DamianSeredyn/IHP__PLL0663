** sch_path: /foss/designs/CHIP-PLL/schematics/vco/vco_tb/vco_dcin_tb.sch
**.subckt vco_dcin_tb
V1 in 0 {vin} ac 1
.save i(v1)
V2 vdd 0 {vdd}
x2 vdd 0 out in vco_core_4
V3 en5 0 1.2
*connector(1,1) ?1 en5
C3 out_pb 0 50f
x14 en5 nen5 vdd 0 inverter
*connector(1,1) ?1 nen5
x3 en5 en11 vdd 0 inverter
*connector(1,1) ?1 en11
x4 en11 nen11 vdd 0 inverter
*connector(1,1) ?1 nen11
*connector(1,1) ?1 nen5
*connector(1,1) ?1 en11
*connector(1,1) ?1 nen11
x1 vdd 0 out_pb out 0_buf
*connector(1,1) ?1 en5
**** begin user architecture code

.param temp=27
.param vdd=1.2
.param vin=0.4

.control

tran 40p 700n
write vco_tb.raw
set appendwrite
plot out
plot out_pb
.endc

 .lib cornerMOSlv.lib mos_tt

**** end user architecture code
**.ends

* expanding   symbol:  /foss/designs/CHIP-PLL/schematics/vco/vco_cell/vco_core_4.sym # of pins=4
** sym_path: /foss/designs/CHIP-PLL/schematics/vco/vco_cell/vco_core_4.sym
** sch_path: /foss/designs/CHIP-PLL/schematics/vco/vco_cell/vco_core_4.sch

* expanding   symbol:  /foss/designs/CHIP-PLL/schematics/divider/schematics/inverter.sym # of pins=4
** sym_path: /foss/designs/CHIP-PLL/schematics/divider/schematics/inverter.sym
** sch_path: /foss/designs/CHIP-PLL/schematics/divider/schematics/inverter.sch
.subckt inverter IN OUT VP GND
*.ipin IN
*.iopin VP
*.opin OUT
*.iopin GND
XM1 OUT IN GND GND sg13_lv_nmos w=0.15u l=0.13u ng=1 m=1 mm_ok=1
XM2 OUT IN VP VP sg13_lv_pmos w=0.15u l=0.13u ng=1 m=1 mm_ok=1
.ends

* expanding   symbol:  /foss/designs/CHIP-PLL/schematics/vco/vco_cell/0_buf.sym # of pins=4
** sym_path: /foss/designs/CHIP-PLL/schematics/vco/vco_cell/0_buf.sym
** sch_path: /foss/designs/CHIP-PLL/schematics/vco/vco_cell/0_buf.sch
.subckt 0_buf vp gnd out in
*.ipin in
*.opin out
*.iopin vp
*.iopin gnd
XM9 3th 2th vp vp sg13_lv_pmos w=2.5u l=0.13u ng=1 m=1 mm_ok=1
XM10 3th 2th gnd gnd sg13_lv_nmos w=2.5u l=0.13u ng=1 m=1 mm_ok=1
XM11 2th 1th vp vp sg13_lv_pmos w=2.4u l=0.13u ng=1 m=1 mm_ok=1
XM12 2th 1th gnd gnd sg13_lv_nmos w=1.2u l=0.13u ng=1 m=1 mm_ok=1
XM1 4th 3th vp vp sg13_lv_pmos w=5u l=0.13u ng=1 m=1 mm_ok=1
XM2 4th 3th gnd gnd sg13_lv_nmos w=5u l=0.13u ng=1 m=1 mm_ok=1
XM3 5th 4th vp vp sg13_lv_pmos w=10u l=0.13u ng=1 m=1 mm_ok=1
XM4 5th 4th gnd gnd sg13_lv_nmos w=10u l=0.13u ng=1 m=1 mm_ok=1
XM5 out 5th vp vp sg13_lv_pmos w=10u l=0.13u ng=1 m=2 mm_ok=1
XM6 out 5th gnd gnd sg13_lv_nmos w=10u l=0.13u ng=1 m=2 mm_ok=1
XM7 1th in gnd gnd sg13_lv_nmos w=0.8u l=0.13u ng=1 m=1 mm_ok=1
XM8 1th in vp vp sg13_lv_pmos w=1.5u l=0.13u ng=1 m=1 mm_ok=1
.ends

* expanding   symbol:  /foss/designs/CHIP-PLL/schematics/vco/vco_cell/vco_delay_cell_4.sym # of pins=6
** sym_path: /foss/designs/CHIP-PLL/schematics/vco/vco_cell/vco_delay_cell_4.sym
** sch_path: /foss/designs/CHIP-PLL/schematics/vco/vco_cell/vco_delay_cell_4.sch
.subckt vco_delay_cell_4 vp pgt in out ngt gnd
*.ipin in
*.opin out
*.iopin gnd
*.iopin vp
*.iopin pgt
*.iopin ngt
XM23 up pgt vp vp sg13_lv_pmos w=1.2u l=7.5*4u ng=1 m=1 mm_ok=1
XM24 out in up vp sg13_lv_pmos w=1.2u l=7.5*2u ng=1 m=1 mm_ok=1
XM25 out in dn gnd sg13_lv_nmos w=0.8u l=7.5*2u ng=1 m=1 mm_ok=1
XM26 dn ngt gnd gnd sg13_lv_nmos w=0.8u l=7.5*4u ng=1 m=1 mm_ok=1
.ends

* ==== BEGIN PEX substitutions (generated by -ext) ====
* ---- PEX adapter dla vco_core_4 ----
*   porty schematu (zachowane): vp gnd out in
*   porty ekstrakcji (xpex):    vp in gnd out
*   zwarcia (brak w ext):       [] -> {'v2i_vp': 'vp'}
.subckt vco_core_4 vp gnd out in
xpex vp in gnd out vco_core_4__pex
.ends
* PEX produced on Mon Nov  9 02:16:45 PM CET 2026 using /foss/tools/sak/sak-pex.sh with m=2 and s=1
* NGSPICE file created from vco_core_4.ext - technology: ihp-sg13cmos5l

.subckt vco_core_4__pex vp in gnd out
X0 vco_delay_cell_4_0.up pgt vp vp sg13_lv_pmos ad=0.408p pd=3.08u as=0.408p ps=3.08u w=1.2u l=30u
X1 vco_delay_cell_4_1.up pgt vp vp sg13_lv_pmos ad=0.408p pd=3.08u as=0.408p ps=3.08u w=1.2u l=30u
X2 vp pgt vco_delay_cell_4_7.up vp sg13_lv_pmos ad=0.408p pd=3.08u as=0.408p ps=3.08u w=1.2u l=30u
X3 vco_delay_cell_4_8.out vco_delay_cell_4_10.out vco_delay_cell_4_8.dn gnd sg13_lv_nmos ad=0.272p pd=2.28u as=0.272p ps=2.28u w=0.8u l=15u
X4 gnd in pgt gnd sg13_lv_nmos ad=0.272p pd=2.28u as=0.272p ps=2.28u w=0.8u l=30u
X5 vp pgt vco_delay_cell_4_8.up vp sg13_lv_pmos ad=0.408p pd=3.08u as=0.408p ps=3.08u w=1.2u l=30u
X6 gnd in vco_delay_cell_4_10.dn gnd sg13_lv_nmos ad=0.272p pd=2.28u as=0.272p ps=2.28u w=0.8u l=30u
X7 vco_delay_cell_4_5.up pgt vp vp sg13_lv_pmos ad=0.408p pd=3.08u as=0.408p ps=3.08u w=1.2u l=30u
X8 vco_delay_cell_4_5.up out vco_delay_cell_4_4.in vp sg13_lv_pmos ad=0.408p pd=3.08u as=0.408p ps=3.08u w=1.2u l=15u
X9 gnd in vco_delay_cell_4_9.dn gnd sg13_lv_nmos ad=0.272p pd=2.28u as=0.272p ps=2.28u w=0.8u l=30u
X10 vco_delay_cell_4_7.out vco_delay_cell_4_8.out vco_delay_cell_4_7.dn gnd sg13_lv_nmos ad=0.272p pd=2.28u as=0.272p ps=2.28u w=0.8u l=15u
X11 vco_delay_cell_4_9.out vco_delay_cell_4_0.out vco_delay_cell_4_9.dn gnd sg13_lv_nmos ad=0.272p pd=2.28u as=0.272p ps=2.28u w=0.8u l=15u
X12 vco_delay_cell_4_4.dn in gnd gnd sg13_lv_nmos ad=0.272p pd=2.28u as=0.272p ps=2.28u w=0.8u l=30u
X13 vco_delay_cell_4_10.out vco_delay_cell_4_9.out vco_delay_cell_4_10.dn gnd sg13_lv_nmos ad=0.272p pd=2.28u as=0.272p ps=2.28u w=0.8u l=15u
X14 gnd in vco_delay_cell_4_6.dn gnd sg13_lv_nmos ad=0.272p pd=2.28u as=0.272p ps=2.28u w=0.8u l=30u
X15 vco_delay_cell_4_3.dn in gnd gnd sg13_lv_nmos ad=0.272p pd=2.28u as=0.272p ps=2.28u w=0.8u l=30u
X16 vco_delay_cell_4_5.dn out vco_delay_cell_4_4.in gnd sg13_lv_nmos ad=0.272p pd=2.28u as=0.272p ps=2.28u w=0.8u l=15u
X17 vp pgt pgt vp sg13_lv_pmos ad=0.408p pd=3.08u as=0.408p ps=3.08u w=1.2u l=30u
X18 vp pgt vco_delay_cell_4_10.up vp sg13_lv_pmos ad=0.408p pd=3.08u as=0.408p ps=3.08u w=1.2u l=30u
X19 out vco_delay_cell_4_7.out vco_delay_cell_4_6.up vp sg13_lv_pmos ad=0.408p pd=3.08u as=0.408p ps=3.08u w=1.2u l=15u
X20 vco_delay_cell_4_0.dn vco_delay_cell_4_0.in vco_delay_cell_4_0.out gnd sg13_lv_nmos ad=0.272p pd=2.28u as=0.272p ps=2.28u w=0.8u l=15u
X21 vp pgt vco_delay_cell_4_9.up vp sg13_lv_pmos ad=0.408p pd=3.08u as=0.408p ps=3.08u w=1.2u l=30u
X22 vco_delay_cell_4_3.dn vco_delay_cell_4_3.in vco_delay_cell_4_2.in gnd sg13_lv_nmos ad=0.272p pd=2.28u as=0.272p ps=2.28u w=0.8u l=15u
X23 vco_delay_cell_4_4.up pgt vp vp sg13_lv_pmos ad=0.408p pd=3.08u as=0.408p ps=3.08u w=1.2u l=30u
X24 vco_delay_cell_4_8.out vco_delay_cell_4_10.out vco_delay_cell_4_8.up vp sg13_lv_pmos ad=0.408p pd=3.08u as=0.408p ps=3.08u w=1.2u l=15u
X25 vco_delay_cell_4_3.up pgt vp vp sg13_lv_pmos ad=0.408p pd=3.08u as=0.408p ps=3.08u w=1.2u l=30u
X26 vp pgt vco_delay_cell_4_6.up vp sg13_lv_pmos ad=0.408p pd=3.08u as=0.408p ps=3.08u w=1.2u l=30u
X27 vco_delay_cell_4_0.dn in gnd gnd sg13_lv_nmos ad=0.272p pd=2.28u as=0.272p ps=2.28u w=0.8u l=30u
X28 vco_delay_cell_4_1.up vco_delay_cell_4_1.in vco_delay_cell_4_0.in vp sg13_lv_pmos ad=0.408p pd=3.08u as=0.408p ps=3.08u w=1.2u l=15u
X29 vco_delay_cell_4_2.dn in gnd gnd sg13_lv_nmos ad=0.272p pd=2.28u as=0.272p ps=2.28u w=0.8u l=30u
X30 vco_delay_cell_4_2.up pgt vp vp sg13_lv_pmos ad=0.408p pd=3.08u as=0.408p ps=3.08u w=1.2u l=30u
X31 vco_delay_cell_4_1.dn in gnd gnd sg13_lv_nmos ad=0.272p pd=2.28u as=0.272p ps=2.28u w=0.8u l=30u
X32 vco_delay_cell_4_7.out vco_delay_cell_4_8.out vco_delay_cell_4_7.up vp sg13_lv_pmos ad=0.408p pd=3.08u as=0.408p ps=3.08u w=1.2u l=15u
X33 vco_delay_cell_4_4.dn vco_delay_cell_4_4.in vco_delay_cell_4_3.in gnd sg13_lv_nmos ad=0.272p pd=2.28u as=0.272p ps=2.28u w=0.8u l=15u
X34 vco_delay_cell_4_9.out vco_delay_cell_4_0.out vco_delay_cell_4_9.up vp sg13_lv_pmos ad=0.408p pd=3.08u as=0.408p ps=3.08u w=1.2u l=15u
X35 vco_delay_cell_4_1.dn vco_delay_cell_4_1.in vco_delay_cell_4_0.in gnd sg13_lv_nmos ad=0.272p pd=2.28u as=0.272p ps=2.28u w=0.8u l=15u
X36 vco_delay_cell_4_0.up vco_delay_cell_4_0.in vco_delay_cell_4_0.out vp sg13_lv_pmos ad=0.408p pd=3.08u as=0.408p ps=3.08u w=1.2u l=15u
X37 gnd in vco_delay_cell_4_7.dn gnd sg13_lv_nmos ad=0.272p pd=2.28u as=0.272p ps=2.28u w=0.8u l=30u
X38 vco_delay_cell_4_10.out vco_delay_cell_4_9.out vco_delay_cell_4_10.up vp sg13_lv_pmos ad=0.408p pd=3.08u as=0.408p ps=3.08u w=1.2u l=15u
X39 vco_delay_cell_4_2.dn vco_delay_cell_4_2.in vco_delay_cell_4_1.in gnd sg13_lv_nmos ad=0.272p pd=2.28u as=0.272p ps=2.28u w=0.8u l=15u
X40 vco_delay_cell_4_5.dn in gnd gnd sg13_lv_nmos ad=0.272p pd=2.28u as=0.272p ps=2.28u w=0.8u l=30u
X41 vco_delay_cell_4_3.up vco_delay_cell_4_3.in vco_delay_cell_4_2.in vp sg13_lv_pmos ad=0.408p pd=3.08u as=0.408p ps=3.08u w=1.2u l=15u
X42 out vco_delay_cell_4_7.out vco_delay_cell_4_6.dn gnd sg13_lv_nmos ad=0.272p pd=2.28u as=0.272p ps=2.28u w=0.8u l=15u
X43 gnd in vco_delay_cell_4_8.dn gnd sg13_lv_nmos ad=0.272p pd=2.28u as=0.272p ps=2.28u w=0.8u l=30u
X44 vco_delay_cell_4_2.up vco_delay_cell_4_2.in vco_delay_cell_4_1.in vp sg13_lv_pmos ad=0.408p pd=3.08u as=0.408p ps=3.08u w=1.2u l=15u
X45 vco_delay_cell_4_4.up vco_delay_cell_4_4.in vco_delay_cell_4_3.in vp sg13_lv_pmos ad=0.408p pd=3.08u as=0.408p ps=3.08u w=1.2u l=15u
C0 vco_delay_cell_4_8.dn pgt 0.02009f
C1 vco_delay_cell_4_6.up vco_delay_cell_4_6.dn 0.03587f
C2 vco_delay_cell_4_8.out in 0.64278f
C3 vco_delay_cell_4_7.out vco_delay_cell_4_6.up 0.08248f
C4 vco_delay_cell_4_5.dn in 0.10573f
C5 vco_delay_cell_4_0.dn in 0.12091f
C6 pgt vco_delay_cell_4_9.up 0.21552f
C7 vco_delay_cell_4_8.out vp 4.40001f
C8 vco_delay_cell_4_5.dn out 0.07813f
C9 vco_delay_cell_4_4.up vco_delay_cell_4_4.dn 0.03587f
C10 pgt vco_delay_cell_4_2.in 0.96674f
C11 vco_delay_cell_4_3.dn in 0.12091f
C12 vco_delay_cell_4_8.out vco_delay_cell_4_7.up 0.08248f
C13 vco_delay_cell_4_9.dn in 0.12061f
C14 vco_delay_cell_4_5.dn vp 0.05179f
C15 vco_delay_cell_4_3.in vco_delay_cell_4_3.up 0.08248f
C16 vco_delay_cell_4_0.dn vp 0.05179f
C17 pgt vco_delay_cell_4_2.up 0.19866f
C18 vco_delay_cell_4_9.dn vco_delay_cell_4_0.out 0.0652f
C19 pgt vco_delay_cell_4_4.up 0.19866f
C20 pgt vco_delay_cell_4_1.up 0.19866f
C21 vco_delay_cell_4_4.in vco_delay_cell_4_4.dn 0.0652f
C22 vco_delay_cell_4_3.dn vp 0.05277f
C23 vco_delay_cell_4_9.dn vp 0.05179f
C24 vco_delay_cell_4_5.dn vco_delay_cell_4_5.up 0.03587f
C25 vco_delay_cell_4_10.out vco_delay_cell_4_9.out 0.11087f
C26 vco_delay_cell_4_10.dn in 0.12061f
C27 vco_delay_cell_4_1.dn vco_delay_cell_4_1.up 0.03587f
C28 pgt vco_delay_cell_4_4.in 0.96674f
C29 vco_delay_cell_4_10.up vco_delay_cell_4_10.dn 0.03587f
C30 vco_delay_cell_4_0.up vco_delay_cell_4_0.in 0.08233f
C31 vco_delay_cell_4_7.out vco_delay_cell_4_8.out 0.11087f
C32 pgt vco_delay_cell_4_6.up 0.21552f
C33 vco_delay_cell_4_10.dn vp 0.05179f
C34 vco_delay_cell_4_8.up vco_delay_cell_4_10.out 0.08248f
C35 pgt vco_delay_cell_4_0.up 0.19866f
C36 vco_delay_cell_4_3.in in 0.64278f
C37 pgt vco_delay_cell_4_9.out 0.965f
C38 vco_delay_cell_4_7.dn vco_delay_cell_4_8.out 0.0652f
C39 vco_delay_cell_4_2.in vco_delay_cell_4_2.up 0.08248f
C40 vco_delay_cell_4_3.up vp 0.61131f
C41 vco_delay_cell_4_3.in vp 4.54785f
C42 pgt vco_delay_cell_4_8.up 0.21552f
C43 vco_delay_cell_4_2.dn in 0.12091f
C44 vco_delay_cell_4_8.out vco_delay_cell_4_10.out 0.11087f
C45 vco_delay_cell_4_1.in in 0.64278f
C46 vco_delay_cell_4_4.up vco_delay_cell_4_4.in 0.08248f
C47 vco_delay_cell_4_2.dn vp 0.05383f
C48 vco_delay_cell_4_0.out in 0.9199f
C49 vco_delay_cell_4_8.dn vco_delay_cell_4_8.up 0.03587f
C50 out in 0.64885f
C51 pgt vco_delay_cell_4_8.out 0.965f
C52 vco_delay_cell_4_1.in vp 4.53299f
C53 vp in 2.43584f
C54 vco_delay_cell_4_0.dn vco_delay_cell_4_0.in 0.06512f
C55 vco_delay_cell_4_10.up vp 0.61015f
C56 vp vco_delay_cell_4_0.out 4.88478f
C57 out vp 3.70849f
C58 pgt vco_delay_cell_4_9.dn 0.02009f
C59 vp vco_delay_cell_4_7.up 0.61015f
C60 vco_delay_cell_4_5.up out 0.06518f
C61 vco_delay_cell_4_5.up vp 0.59265f
C62 vco_delay_cell_4_6.dn in 0.12061f
C63 pgt vco_delay_cell_4_10.dn 0.02009f
C64 vco_delay_cell_4_7.out in 0.63755f
C65 vco_delay_cell_4_7.out out 0.14665f
C66 vco_delay_cell_4_7.dn in 0.12061f
C67 vco_delay_cell_4_6.dn vp 0.05179f
C68 vco_delay_cell_4_9.dn vco_delay_cell_4_9.up 0.03587f
C69 pgt vco_delay_cell_4_3.up 0.19866f
C70 vco_delay_cell_4_7.out vp 4.20193f
C71 pgt vco_delay_cell_4_3.in 0.96674f
C72 vco_delay_cell_4_7.dn vp 0.05179f
C73 vco_delay_cell_4_10.out in 0.64278f
C74 vco_delay_cell_4_7.dn vco_delay_cell_4_7.up 0.03587f
C75 vco_delay_cell_4_4.dn in 0.12091f
C76 vco_delay_cell_4_1.in vco_delay_cell_4_0.in 0.11087f
C77 vco_delay_cell_4_0.in in 0.63748f
C78 vco_delay_cell_4_10.out vp 4.53827f
C79 vco_delay_cell_4_0.dn vco_delay_cell_4_0.up 0.03587f
C80 pgt vco_delay_cell_4_1.in 0.96674f
C81 vco_delay_cell_4_0.in vco_delay_cell_4_0.out 0.14049f
C82 vco_delay_cell_4_7.out vco_delay_cell_4_6.dn 0.0652f
C83 pgt in 1.89828f
C84 pgt vco_delay_cell_4_0.out 1.10325f
C85 pgt vco_delay_cell_4_10.up 0.21552f
C86 vco_delay_cell_4_4.dn vp 0.05373f
C87 vco_delay_cell_4_3.in vco_delay_cell_4_2.in 0.11087f
C88 pgt out 0.63186f
C89 vco_delay_cell_4_0.in vp 4.19427f
C90 vco_delay_cell_4_1.dn vco_delay_cell_4_1.in 0.0652f
C91 vco_delay_cell_4_1.dn in 0.12091f
C92 pgt vp 0.12434p
C93 vco_delay_cell_4_8.dn in 0.12061f
C94 pgt vco_delay_cell_4_7.up 0.21552f
C95 vco_delay_cell_4_2.dn vco_delay_cell_4_2.in 0.0652f
C96 vco_delay_cell_4_1.dn vp 0.05308f
C97 vco_delay_cell_4_10.dn vco_delay_cell_4_9.out 0.0652f
C98 vco_delay_cell_4_3.in vco_delay_cell_4_4.in 0.11087f
C99 pgt vco_delay_cell_4_5.up 0.1794f
C100 vco_delay_cell_4_8.dn vp 0.05203f
C101 vco_delay_cell_4_2.dn vco_delay_cell_4_2.up 0.03587f
C102 vco_delay_cell_4_9.up vco_delay_cell_4_0.out 0.08248f
C103 vco_delay_cell_4_2.in vco_delay_cell_4_1.in 0.11087f
C104 vco_delay_cell_4_2.in in 0.64278f
C105 vco_delay_cell_4_9.up vp 0.61015f
C106 vco_delay_cell_4_1.in vco_delay_cell_4_1.up 0.08248f
C107 pgt vco_delay_cell_4_6.dn 0.02009f
C108 pgt vco_delay_cell_4_7.out 0.95874f
C109 vco_delay_cell_4_2.in vp 4.50637f
C110 vp vco_delay_cell_4_2.up 0.61251f
C111 vco_delay_cell_4_4.in in 0.64278f
C112 pgt vco_delay_cell_4_7.dn 0.02009f
C113 vp vco_delay_cell_4_1.up 0.61166f
C114 vco_delay_cell_4_4.up vp 0.61239f
C115 vco_delay_cell_4_4.in out 0.11087f
C116 vco_delay_cell_4_4.in vp 4.50788f
C117 vco_delay_cell_4_9.out in 0.64278f
C118 pgt vco_delay_cell_4_10.out 0.965f
C119 vco_delay_cell_4_9.out vco_delay_cell_4_0.out 0.11087f
C120 vco_delay_cell_4_10.up vco_delay_cell_4_9.out 0.08248f
C121 vco_delay_cell_4_6.up vp 0.61015f
C122 vco_delay_cell_4_0.up vp 0.61015f
C123 vco_delay_cell_4_9.out vp 4.3969f
C124 pgt vco_delay_cell_4_0.in 0.95872f
C125 vco_delay_cell_4_8.dn vco_delay_cell_4_10.out 0.0652f
C126 vco_delay_cell_4_3.dn vco_delay_cell_4_3.up 0.03587f
C127 vco_delay_cell_4_3.dn vco_delay_cell_4_3.in 0.0652f
C128 vco_delay_cell_4_8.up vp 0.61045f
C129 out gnd 3.71837f
C130 vp gnd 48.19655f
C131 vco_delay_cell_4_5.up gnd 2.0597f
C132 vco_delay_cell_4_4.up gnd 0.07074f
C133 vco_delay_cell_4_3.up gnd 1.51298f
C134 vco_delay_cell_4_2.up gnd 0.79186f
C135 vco_delay_cell_4_1.up gnd 1.97117f
C136 vco_delay_cell_4_0.up gnd 10.93691f
C137 vco_delay_cell_4_1.in gnd 3.57176f
C138 vco_delay_cell_4_5.dn gnd 0.65601f
C139 vco_delay_cell_4_4.dn gnd 3.53806f
C140 vco_delay_cell_4_3.dn gnd 2.55403f
C141 vco_delay_cell_4_2.dn gnd 3.50424f
C142 vco_delay_cell_4_1.dn gnd 0.6536f
C143 vco_delay_cell_4_0.dn gnd 2.55405f
C144 vco_delay_cell_4_6.dn gnd 1.04621f
C145 vco_delay_cell_4_7.dn gnd 3.50424f
C146 vco_delay_cell_4_8.dn gnd 2.55403f
C147 vco_delay_cell_4_10.dn gnd 3.79451f
C148 vco_delay_cell_4_9.dn gnd 3.13456f
C149 vco_delay_cell_4_10.out gnd 0.47511f
C150 vco_delay_cell_4_0.out gnd 0.95021f
C151 vco_delay_cell_4_6.up gnd 3.39649f
C152 vco_delay_cell_4_7.up gnd 0.85597f
C153 vco_delay_cell_4_8.up gnd 27.1662f
C154 vco_delay_cell_4_10.up gnd 0.54586f
C155 vco_delay_cell_4_9.up gnd 1.02097f
.ends
* ==== END PEX substitutions ====
.end
