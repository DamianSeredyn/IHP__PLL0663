** sch_path: /foss/designs/CHIP-PLL/schematics/vco/vco_tb/vco_dcin_tb.sch
**.subckt vco_dcin_tb
V1 in 0 {vin} ac 1
.save i(v1)
V2 vdd 0 {vdd}
x2 vdd 0 out in en5 nen5 nen11 en11 vco_core_3
V3 en5 0 1.2
*connector(1,1) ?1 en5
C3 out_pb 0 50f
x14 en5 nen5 vdd 0 inverter
*connector(1,1) ?1 nen5
x3 en5 en11 vdd 0 inverter
*connector(1,1) ?1 en11
x4 en11 nen11 vdd 0 inverter
*connector(1,1) ?1 nen11
*connector(1,1) ?1 nen5
*connector(1,1) ?1 en11
*connector(1,1) ?1 nen11
x1 vdd 0 out_pb out 0_buf
*connector(1,1) ?1 en5
**** begin user architecture code

.param temp=27
.param vdd=1.2
.param vin=0.4

.control

tran 40p 700n
write vco_tb.raw
set appendwrite
plot out
plot out_pb
.endc

 .lib cornerMOSlv.lib mos_tt

**** end user architecture code
**.ends

* expanding   symbol:  /foss/designs/CHIP-PLL/schematics/vco/vco_cell/vco_core_3.sym # of pins=8
** sym_path: /foss/designs/CHIP-PLL/schematics/vco/vco_cell/vco_core_3.sym
** sch_path: /foss/designs/CHIP-PLL/schematics/vco/vco_cell/vco_core_3.sch

* expanding   symbol:  /foss/designs/CHIP-PLL/schematics/divider/schematics/inverter.sym # of pins=4
** sym_path: /foss/designs/CHIP-PLL/schematics/divider/schematics/inverter.sym
** sch_path: /foss/designs/CHIP-PLL/schematics/divider/schematics/inverter.sch
.subckt inverter IN OUT VP GND
*.ipin IN
*.iopin VP
*.opin OUT
*.iopin GND
XM1 OUT IN GND GND sg13_lv_nmos w=0.15u l=0.13u ng=1 m=1 mm_ok=1
XM2 OUT IN VP VP sg13_lv_pmos w=0.15u l=0.13u ng=1 m=1 mm_ok=1
.ends

* expanding   symbol:  /foss/designs/CHIP-PLL/schematics/vco/vco_cell/0_buf.sym # of pins=4
** sym_path: /foss/designs/CHIP-PLL/schematics/vco/vco_cell/0_buf.sym
** sch_path: /foss/designs/CHIP-PLL/schematics/vco/vco_cell/0_buf.sch
.subckt 0_buf vp gnd out in
*.ipin in
*.opin out
*.iopin vp
*.iopin gnd
XM9 3th 2th vp vp sg13_lv_pmos w=2.5u l=0.13u ng=1 m=1 mm_ok=1
XM10 3th 2th gnd gnd sg13_lv_nmos w=2.5u l=0.13u ng=1 m=1 mm_ok=1
XM11 2th 1th vp vp sg13_lv_pmos w=2.4u l=0.13u ng=1 m=1 mm_ok=1
XM12 2th 1th gnd gnd sg13_lv_nmos w=1.2u l=0.13u ng=1 m=1 mm_ok=1
XM1 4th 3th vp vp sg13_lv_pmos w=5u l=0.13u ng=1 m=1 mm_ok=1
XM2 4th 3th gnd gnd sg13_lv_nmos w=5u l=0.13u ng=1 m=1 mm_ok=1
XM3 5th 4th vp vp sg13_lv_pmos w=10u l=0.13u ng=1 m=1 mm_ok=1
XM4 5th 4th gnd gnd sg13_lv_nmos w=10u l=0.13u ng=1 m=1 mm_ok=1
XM5 out 5th vp vp sg13_lv_pmos w=10u l=0.13u ng=1 m=2 mm_ok=1
XM6 out 5th gnd gnd sg13_lv_nmos w=10u l=0.13u ng=1 m=2 mm_ok=1
XM7 1th in gnd gnd sg13_lv_nmos w=0.8u l=0.13u ng=1 m=1 mm_ok=1
XM8 1th in vp vp sg13_lv_pmos w=1.5u l=0.13u ng=1 m=1 mm_ok=1
.ends

* expanding   symbol:  /foss/designs/CHIP-PLL/schematics/vco/vco_cell/vco_delay_cell_3.sym # of pins=6
** sym_path: /foss/designs/CHIP-PLL/schematics/vco/vco_cell/vco_delay_cell_3.sym
** sch_path: /foss/designs/CHIP-PLL/schematics/vco/vco_cell/vco_delay_cell_3.sch
.subckt vco_delay_cell_3 vp pgt in out ngt gnd
*.ipin in
*.opin out
*.iopin gnd
*.iopin vp
*.iopin pgt
*.iopin ngt
XM23 up pgt vp vp sg13_lv_pmos w=1.2u l=4.25*4u ng=1 m=1 mm_ok=1
XM24 out in up vp sg13_lv_pmos w=1.2u l=4.25*2u ng=1 m=1 mm_ok=1
XM25 out in dn gnd sg13_lv_nmos w=0.8u l=4.25*2u ng=1 m=1 mm_ok=1
XM26 dn ngt gnd gnd sg13_lv_nmos w=0.8u l=4.25*4u ng=1 m=1 mm_ok=1
.ends

* expanding   symbol:  /foss/designs/CHIP-PLL/schematics/divider/schematics/passgate.sym # of pins=6
** sym_path: /foss/designs/CHIP-PLL/schematics/divider/schematics/passgate.sym
** sch_path: /foss/designs/CHIP-PLL/schematics/divider/schematics/passgate.sch
.subckt passgate in_p vp gnd in_n A B
*.ipin in_n
*.ipin in_p
*.iopin vp
*.iopin gnd
*.iopin B
*.iopin A
XM4 B in_p A vp sg13_lv_pmos w=0.3u l=0.15u ng=1 m=1 mm_ok=1
XM5 B in_n A gnd sg13_lv_nmos w=0.3u l=0.15u ng=1 m=1 mm_ok=1
.ends

* ==== BEGIN PEX substitutions (generated by -ext) ====
* ---- PEX adapter dla vco_core_3 ----
*   porty schematu (zachowane): vp gnd out in en5 nen5 nen11 en11
*   porty ekstrakcji (xpex):    in out en11 nen11 nen5 gnd vp en5
*   zwarcia (brak w ext):       [] -> {'v2i_vp': 'vp'}
.subckt vco_core_3 vp gnd out in en5 nen5 nen11 en11
xpex in out en11 nen11 nen5 gnd vp en5 vco_core_3__pex
.ends
* PEX produced on Mon Nov  9 02:16:39 PM CET 2026 using /foss/tools/sak/sak-pex.sh with m=2 and s=1
* NGSPICE file created from vco_core_3.ext - technology: ihp-sg13cmos5l

.subckt vco_core_3__pex in out en11 nen11 nen5 gnd vp en5
X0 vco_delay_cell_3_5.in nen11 vco_delay_cell_3_7.out vp sg13_lv_pmos ad=0.102p pd=1.28u as=0.102p ps=1.28u w=0.3u l=0.15u
X1 vco_delay_cell_3_6.out vco_delay_cell_3_5.out a_n1549_n3048# vp sg13_lv_pmos ad=0.408p pd=3.08u as=0.408p ps=3.08u w=1.2u l=8.5u
X2 vp vco_delay_cell_3_5.pgt a_9671_748# vp sg13_lv_pmos ad=0.408p pd=3.08u as=0.408p ps=3.08u w=1.2u l=17u
X3 vp vco_delay_cell_3_5.pgt a_14227_748# vp sg13_lv_pmos ad=0.408p pd=3.08u as=0.408p ps=3.08u w=1.2u l=17u
X4 vco_delay_cell_3_7.out vco_delay_cell_3_8.out a_9671_748# vp sg13_lv_pmos ad=0.408p pd=3.08u as=0.408p ps=3.08u w=1.2u l=8.5u
X5 vp vco_delay_cell_3_5.pgt vco_delay_cell_3_5.pgt vp sg13_lv_pmos ad=0.408p pd=3.08u as=0.408p ps=3.08u w=1.2u l=17u
X6 vco_delay_cell_3_0.in nen5 vco_delay_cell_3_7.out vp sg13_lv_pmos ad=0.102p pd=1.28u as=0.102p ps=1.28u w=0.3u l=0.15u
X7 out vco_delay_cell_3_0.in a_14227_748# vp sg13_lv_pmos ad=0.408p pd=3.08u as=0.408p ps=3.08u w=1.2u l=8.5u
X8 gnd in a_9671_n714# gnd sg13_lv_nmos ad=0.272p pd=2.28u as=0.272p ps=2.28u w=0.8u l=17u
X9 vp vco_delay_cell_3_5.pgt a_9671_n3048# vp sg13_lv_pmos ad=0.408p pd=3.08u as=0.408p ps=3.08u w=1.2u l=17u
X10 gnd in a_9671_n1506# gnd sg13_lv_nmos ad=0.272p pd=2.28u as=0.272p ps=2.28u w=0.8u l=17u
X11 gnd in a_5931_n714# gnd sg13_lv_nmos ad=0.272p pd=2.28u as=0.272p ps=2.28u w=0.8u l=17u
X12 vp vco_delay_cell_3_5.pgt a_n1549_n3048# vp sg13_lv_pmos ad=0.408p pd=3.08u as=0.408p ps=3.08u w=1.2u l=17u
X13 vco_delay_cell_3_4.out vco_delay_cell_3_6.out a_2191_n1506# gnd sg13_lv_nmos ad=0.272p pd=2.28u as=0.272p ps=2.28u w=0.8u l=8.5u
X14 vco_delay_cell_3_4.out vco_delay_cell_3_6.out a_2191_n3048# vp sg13_lv_pmos ad=0.408p pd=3.08u as=0.408p ps=3.08u w=1.2u l=8.5u
X15 gnd in a_n1549_n1506# gnd sg13_lv_nmos ad=0.272p pd=2.28u as=0.272p ps=2.28u w=0.8u l=17u
X16 vp vco_delay_cell_3_5.pgt a_2191_n3048# vp sg13_lv_pmos ad=0.408p pd=3.08u as=0.408p ps=3.08u w=1.2u l=17u
X17 gnd in vco_delay_cell_3_5.pgt gnd sg13_lv_nmos ad=0.272p pd=2.28u as=0.272p ps=2.28u w=0.8u l=17u
X18 gnd in a_2191_n1506# gnd sg13_lv_nmos ad=0.272p pd=2.28u as=0.272p ps=2.28u w=0.8u l=17u
X19 vco_delay_cell_3_2.out vco_delay_cell_3_3.out a_9671_n1506# gnd sg13_lv_nmos ad=0.272p pd=2.28u as=0.272p ps=2.28u w=0.8u l=8.5u
X20 vco_delay_cell_3_5.in en11 vco_delay_cell_3_7.out gnd sg13_lv_nmos ad=0.102p pd=1.28u as=0.102p ps=1.28u w=0.3u l=0.15u
X21 vco_delay_cell_3_2.out vco_delay_cell_3_3.out a_9671_n3048# vp sg13_lv_pmos ad=0.408p pd=3.08u as=0.408p ps=3.08u w=1.2u l=8.5u
X22 gnd in a_n1549_n714# gnd sg13_lv_nmos ad=0.272p pd=2.28u as=0.272p ps=2.28u w=0.8u l=17u
X23 gnd in a_2191_n714# gnd sg13_lv_nmos ad=0.272p pd=2.28u as=0.272p ps=2.28u w=0.8u l=17u
X24 vco_delay_cell_3_0.in en5 vco_delay_cell_3_7.out gnd sg13_lv_nmos ad=0.102p pd=1.28u as=0.102p ps=1.28u w=0.3u l=0.15u
X25 vco_delay_cell_3_7.out vco_delay_cell_3_8.out a_9671_n714# gnd sg13_lv_nmos ad=0.272p pd=2.28u as=0.272p ps=2.28u w=0.8u l=8.5u
X26 out vco_delay_cell_3_0.in a_14227_n714# gnd sg13_lv_nmos ad=0.272p pd=2.28u as=0.272p ps=2.28u w=0.8u l=8.5u
X27 vco_delay_cell_3_1.out vco_delay_cell_3_2.out a_13411_n1506# gnd sg13_lv_nmos ad=0.272p pd=2.28u as=0.272p ps=2.28u w=0.8u l=8.5u
X28 vco_delay_cell_3_1.out vco_delay_cell_3_2.out a_13411_n3048# vp sg13_lv_pmos ad=0.408p pd=3.08u as=0.408p ps=3.08u w=1.2u l=8.5u
X29 vco_delay_cell_3_3.out vco_delay_cell_3_4.out a_5931_n1506# gnd sg13_lv_nmos ad=0.272p pd=2.28u as=0.272p ps=2.28u w=0.8u l=8.5u
X30 vp vco_delay_cell_3_5.pgt a_13411_n3048# vp sg13_lv_pmos ad=0.408p pd=3.08u as=0.408p ps=3.08u w=1.2u l=17u
X31 gnd in a_13411_n1506# gnd sg13_lv_nmos ad=0.272p pd=2.28u as=0.272p ps=2.28u w=0.8u l=17u
X32 vco_delay_cell_3_3.out vco_delay_cell_3_4.out a_5931_n3048# vp sg13_lv_pmos ad=0.408p pd=3.08u as=0.408p ps=3.08u w=1.2u l=8.5u
X33 vp vco_delay_cell_3_5.pgt a_5931_n3048# vp sg13_lv_pmos ad=0.408p pd=3.08u as=0.408p ps=3.08u w=1.2u l=17u
X34 vco_delay_cell_3_5.out vco_delay_cell_3_5.in a_n5289_n1506# gnd sg13_lv_nmos ad=0.272p pd=2.28u as=0.272p ps=2.28u w=0.8u l=8.5u
X35 vco_delay_cell_3_5.out vco_delay_cell_3_5.in a_n5289_n3048# vp sg13_lv_pmos ad=0.408p pd=3.08u as=0.408p ps=3.08u w=1.2u l=8.5u
X36 gnd in a_5931_n1506# gnd sg13_lv_nmos ad=0.272p pd=2.28u as=0.272p ps=2.28u w=0.8u l=17u
X37 vco_delay_cell_3_10.out out a_n1549_748# vp sg13_lv_pmos ad=0.408p pd=3.08u as=0.408p ps=3.08u w=1.2u l=8.5u
X38 vco_delay_cell_3_0.in nen11 vco_delay_cell_3_1.out vp sg13_lv_pmos ad=0.102p pd=1.28u as=0.102p ps=1.28u w=0.3u l=0.15u
X39 vp vco_delay_cell_3_5.pgt a_2191_748# vp sg13_lv_pmos ad=0.408p pd=3.08u as=0.408p ps=3.08u w=1.2u l=17u
X40 vco_delay_cell_3_8.out vco_delay_cell_3_9.out a_5931_n714# gnd sg13_lv_nmos ad=0.272p pd=2.28u as=0.272p ps=2.28u w=0.8u l=8.5u
X41 vp vco_delay_cell_3_5.pgt a_n5289_n3048# vp sg13_lv_pmos ad=0.408p pd=3.08u as=0.408p ps=3.08u w=1.2u l=17u
X42 vco_delay_cell_3_9.out vco_delay_cell_3_10.out a_2191_748# vp sg13_lv_pmos ad=0.408p pd=3.08u as=0.408p ps=3.08u w=1.2u l=8.5u
X43 vco_delay_cell_3_0.in en11 vco_delay_cell_3_1.out gnd sg13_lv_nmos ad=0.102p pd=1.28u as=0.102p ps=1.28u w=0.3u l=0.15u
X44 gnd in a_n5289_n1506# gnd sg13_lv_nmos ad=0.272p pd=2.28u as=0.272p ps=2.28u w=0.8u l=17u
X45 vp vco_delay_cell_3_5.pgt a_n1549_748# vp sg13_lv_pmos ad=0.408p pd=3.08u as=0.408p ps=3.08u w=1.2u l=17u
X46 vp vco_delay_cell_3_5.pgt a_5931_748# vp sg13_lv_pmos ad=0.408p pd=3.08u as=0.408p ps=3.08u w=1.2u l=17u
X47 vco_delay_cell_3_8.out vco_delay_cell_3_9.out a_5931_748# vp sg13_lv_pmos ad=0.408p pd=3.08u as=0.408p ps=3.08u w=1.2u l=8.5u
X48 vco_delay_cell_3_10.out out a_n1549_n714# gnd sg13_lv_nmos ad=0.272p pd=2.28u as=0.272p ps=2.28u w=0.8u l=8.5u
X49 vco_delay_cell_3_9.out vco_delay_cell_3_10.out a_2191_n714# gnd sg13_lv_nmos ad=0.272p pd=2.28u as=0.272p ps=2.28u w=0.8u l=8.5u
X50 gnd in a_14227_n714# gnd sg13_lv_nmos ad=0.272p pd=2.28u as=0.272p ps=2.28u w=0.8u l=17u
X51 vco_delay_cell_3_6.out vco_delay_cell_3_5.out a_n1549_n1506# gnd sg13_lv_nmos ad=0.272p pd=2.28u as=0.272p ps=2.28u w=0.8u l=8.5u
C0 a_n1549_748# out 0.05979f
C1 a_9671_n714# vco_delay_cell_3_5.in 0.10114f
C2 vco_delay_cell_3_5.pgt in 2.4019f
C3 vp a_n1549_n1506# 0.0372f
C4 a_2191_n1506# vp 0.03842f
C5 a_n1549_n714# out 0.04124f
C6 a_5931_n1506# in 0.23521f
C7 vco_delay_cell_3_9.out vco_delay_cell_3_8.out 0.16384f
C8 vco_delay_cell_3_5.out a_n1549_n1506# 0.05096f
C9 vco_delay_cell_3_5.in vco_delay_cell_3_7.out 0.60303f
C10 vco_delay_cell_3_2.out vp 2.67133f
C11 a_n5289_n1506# vco_delay_cell_3_5.in 0.04376f
C12 out vco_delay_cell_3_10.out 0.37921f
C13 vp vco_delay_cell_3_5.in 2.85573f
C14 vco_delay_cell_3_2.out a_13411_n1506# 0.05096f
C15 out a_14227_748# 0.04816f
C16 in vco_delay_cell_3_4.out 0.57024f
C17 a_9671_748# a_9671_n714# 0.01952f
C18 vco_delay_cell_3_5.in vco_delay_cell_3_5.out 0.16626f
C19 vco_delay_cell_3_3.out vp 2.79027f
C20 vco_delay_cell_3_0.in a_14227_748# 0.06863f
C21 a_n1549_n3048# vp 0.40529f
C22 vco_delay_cell_3_0.in a_14227_n714# 0.07459f
C23 vco_delay_cell_3_5.pgt en11 0.07128f
C24 a_n1549_n3048# vco_delay_cell_3_5.out 0.06619f
C25 a_9671_n714# vco_delay_cell_3_8.out 0.04645f
C26 vco_delay_cell_3_5.pgt out 5.39291f
C27 a_9671_748# vp 0.40766f
C28 vco_delay_cell_3_5.pgt vco_delay_cell_3_0.in 0.41487f
C29 vco_delay_cell_3_9.out a_5931_n714# 0.04645f
C30 vco_delay_cell_3_9.out vco_delay_cell_3_10.out 0.16384f
C31 a_2191_n714# vco_delay_cell_3_10.out 0.04645f
C32 vco_delay_cell_3_8.out vco_delay_cell_3_7.out 0.16437f
C33 in vco_delay_cell_3_1.out 0.01396f
C34 vco_delay_cell_3_5.pgt nen11 0.66686f
C35 vp vco_delay_cell_3_8.out 2.77927f
C36 vco_delay_cell_3_5.pgt a_n5289_n3048# 0.27075f
C37 a_n1549_n3048# a_n1549_n1506# 0.01952f
C38 out a_2191_748# 0.05572f
C39 nen5 a_14227_748# 0.1022f
C40 nen11 a_13411_n3048# 0.09025f
C41 vco_delay_cell_3_2.out vco_delay_cell_3_3.out 0.16384f
C42 a_n1549_748# vp 0.40529f
C43 vco_delay_cell_3_9.out vco_delay_cell_3_5.pgt 0.75171f
C44 vp a_9671_n3048# 0.40785f
C45 vco_delay_cell_3_5.pgt nen5 0.5167f
C46 vco_delay_cell_3_5.pgt vco_delay_cell_3_6.out 0.54549f
C47 a_n1549_n714# vp 0.03719f
C48 a_5931_748# out 0.05572f
C49 en11 vco_delay_cell_3_1.out 0.0684f
C50 a_2191_n714# a_2191_748# 0.01952f
C51 a_9671_n1506# in 0.23521f
C52 a_5931_n714# vp 0.03713f
C53 vp vco_delay_cell_3_10.out 2.74178f
C54 vco_delay_cell_3_0.in vco_delay_cell_3_1.out 0.25683f
C55 vp a_14227_748# 0.39086f
C56 vco_delay_cell_3_5.in vco_delay_cell_3_8.out 0.35129f
C57 vco_delay_cell_3_6.out vco_delay_cell_3_4.out 0.16384f
C58 a_14227_n714# vp 0.03787f
C59 nen11 vco_delay_cell_3_1.out 0.08365f
C60 vco_delay_cell_3_5.pgt vco_delay_cell_3_7.out 0.02151f
C61 vco_delay_cell_3_9.out a_5931_748# 0.0657f
C62 en5 a_14227_n714# 0.07909f
C63 vco_delay_cell_3_5.pgt vp 80.2285f
C64 vco_delay_cell_3_5.pgt a_n5289_n1506# 0.01323f
C65 en11 in 1.30868f
C66 vco_delay_cell_3_5.pgt vco_delay_cell_3_5.out 0.64618f
C67 vco_delay_cell_3_3.out a_9671_n3048# 0.06619f
C68 a_9671_748# vco_delay_cell_3_8.out 0.0657f
C69 a_5931_n1506# vp 0.03713f
C70 a_n1549_n714# vco_delay_cell_3_5.in 0.10114f
C71 a_13411_n3048# vp 0.40519f
C72 in out 0.33382f
C73 en5 vco_delay_cell_3_5.pgt 0.06782f
C74 a_13411_n3048# a_13411_n1506# 0.01952f
C75 vp a_5931_n3048# 0.40519f
C76 vco_delay_cell_3_0.in in 0.54372f
C77 a_5931_n714# vco_delay_cell_3_5.in 0.10114f
C78 vp a_2191_748# 0.40656f
C79 vp vco_delay_cell_3_4.out 2.69018f
C80 vco_delay_cell_3_5.in vco_delay_cell_3_10.out 0.35098f
C81 nen11 in 0.14385f
C82 vco_delay_cell_3_5.pgt a_n1549_n1506# 0.02106f
C83 a_2191_n3048# vco_delay_cell_3_6.out 0.06619f
C84 vco_delay_cell_3_2.out vco_delay_cell_3_5.pgt 0.64248f
C85 vco_delay_cell_3_9.out in 0.33702f
C86 a_2191_n714# in 0.22557f
C87 vco_delay_cell_3_5.pgt vco_delay_cell_3_5.in 0.75942f
C88 a_5931_748# vp 0.40519f
C89 in nen5 0.02529f
C90 en11 vco_delay_cell_3_0.in 0.07699f
C91 vco_delay_cell_3_2.out a_13411_n3048# 0.06489f
C92 vco_delay_cell_3_5.pgt vco_delay_cell_3_3.out 0.77704f
C93 vp vco_delay_cell_3_1.out 0.61329f
C94 in vco_delay_cell_3_6.out 0.58284f
C95 vco_delay_cell_3_5.pgt a_n1549_n3048# 0.28312f
C96 vco_delay_cell_3_0.in out 0.27577f
C97 a_n1549_748# a_n1549_n714# 0.01952f
C98 nen11 en11 0.51313f
C99 nen11 out 0.09199f
C100 a_9671_n714# in 0.22557f
C101 a_9671_748# vco_delay_cell_3_5.pgt 0.25023f
C102 a_2191_n3048# vp 0.40668f
C103 nen11 vco_delay_cell_3_0.in 0.09196f
C104 vco_delay_cell_3_3.out vco_delay_cell_3_4.out 0.16384f
C105 vco_delay_cell_3_9.out out 0.20776f
C106 vco_delay_cell_3_5.pgt vco_delay_cell_3_8.out 0.59557f
C107 in vco_delay_cell_3_7.out 0.01814f
C108 in vp 2.4986f
C109 out nen5 0.3744f
C110 a_n5289_n1506# in 0.21566f
C111 a_9671_n1506# vp 0.03946f
C112 in a_13411_n1506# 0.22858f
C113 vco_delay_cell_3_2.out vco_delay_cell_3_1.out 0.16488f
C114 a_n1549_748# vco_delay_cell_3_5.pgt 0.2833f
C115 in vco_delay_cell_3_5.out 0.56995f
C116 vco_delay_cell_3_0.in nen5 0.39823f
C117 vco_delay_cell_3_5.pgt a_9671_n3048# 0.25993f
C118 a_2191_n3048# a_2191_n1506# 0.01952f
C119 en5 in 1.4843f
C120 nen11 nen5 0.07546f
C121 vco_delay_cell_3_5.pgt a_n1549_n714# 0.0144f
C122 a_14227_n714# a_14227_748# 0.01952f
C123 en11 vco_delay_cell_3_7.out 0.02419f
C124 in a_n1549_n1506# 0.23521f
C125 a_2191_n1506# in 0.23521f
C126 vco_delay_cell_3_5.pgt vco_delay_cell_3_10.out 0.36908f
C127 out vco_delay_cell_3_7.out 0.06333f
C128 en11 vp 0.11793f
C129 vco_delay_cell_3_5.pgt a_14227_748# 0.26291f
C130 en11 a_13411_n1506# 0.04372f
C131 out vp 3.9129f
C132 vco_delay_cell_3_0.in vco_delay_cell_3_7.out 0.34959f
C133 vco_delay_cell_3_2.out in 0.42319f
C134 vco_delay_cell_3_5.pgt a_14227_n714# 0.01612f
C135 in vco_delay_cell_3_5.in 3.73785f
C136 vco_delay_cell_3_0.in vp 3.07113f
C137 en5 en11 0.06176f
C138 nen11 vco_delay_cell_3_7.out 0.0761f
C139 vco_delay_cell_3_3.out in 0.57024f
C140 vco_delay_cell_3_10.out a_2191_748# 0.0657f
C141 a_9671_n1506# vco_delay_cell_3_3.out 0.05096f
C142 nen11 vp 1.4162f
C143 vp a_n5289_n3048# 0.40452f
C144 a_n5289_n1506# a_n5289_n3048# 0.01952f
C145 en5 vco_delay_cell_3_0.in 0.62491f
C146 nen11 a_13411_n1506# 0.01598f
C147 vco_delay_cell_3_5.pgt a_13411_n3048# 0.25491f
C148 en5 nen11 0.0163f
C149 vco_delay_cell_3_5.pgt a_5931_n3048# 0.26202f
C150 vco_delay_cell_3_9.out vp 2.68206f
C151 a_2191_n714# vp 0.03777f
C152 vco_delay_cell_3_2.out en11 0.18305f
C153 vco_delay_cell_3_5.pgt vco_delay_cell_3_4.out 0.93555f
C154 vco_delay_cell_3_5.pgt a_2191_748# 0.24606f
C155 a_5931_n1506# a_5931_n3048# 0.01952f
C156 a_5931_748# a_5931_n714# 0.01952f
C157 en11 vco_delay_cell_3_5.in 0.05157f
C158 nen5 vp 0.81395f
C159 in vco_delay_cell_3_8.out 0.33702f
C160 vp vco_delay_cell_3_6.out 2.75724f
C161 out vco_delay_cell_3_5.in 0.26031f
C162 a_5931_n1506# vco_delay_cell_3_4.out 0.05096f
C163 vco_delay_cell_3_6.out vco_delay_cell_3_5.out 0.16384f
C164 a_5931_n3048# vco_delay_cell_3_4.out 0.06619f
C165 en5 nen5 0.02314f
C166 vco_delay_cell_3_2.out nen11 0.31701f
C167 a_9671_n714# vp 0.03815f
C168 nen11 vco_delay_cell_3_5.in 0.0394f
C169 vco_delay_cell_3_5.pgt a_5931_748# 0.25216f
C170 vco_delay_cell_3_5.in a_n5289_n3048# 0.05782f
C171 a_9671_n1506# a_9671_n3048# 0.01952f
C172 a_9671_748# out 0.05572f
C173 vco_delay_cell_3_5.pgt vco_delay_cell_3_1.out 0.01137f
C174 a_n1549_n714# in 0.22557f
C175 a_2191_n1506# vco_delay_cell_3_6.out 0.05096f
C176 vp vco_delay_cell_3_7.out 0.6168f
C177 vco_delay_cell_3_9.out vco_delay_cell_3_5.in 0.35098f
C178 a_2191_n714# vco_delay_cell_3_5.in 0.10114f
C179 a_n5289_n1506# vp 0.06879f
C180 a_5931_n714# in 0.22557f
C181 out vco_delay_cell_3_8.out 0.20776f
C182 vp a_13411_n1506# 0.03713f
C183 in vco_delay_cell_3_10.out 0.34847f
C184 vp vco_delay_cell_3_5.out 2.75826f
C185 en5 vco_delay_cell_3_7.out 0.01442f
C186 a_2191_n3048# vco_delay_cell_3_5.pgt 0.25575f
C187 a_14227_n714# in 0.22004f
C188 en5 vp 0.16838f
C189 vp gnd 12.61333f
C190 a_13411_n3048# gnd 0.04485f
C191 a_9671_n3048# gnd 0.04485f
C192 a_5931_n3048# gnd 0.04485f
C193 a_2191_n3048# gnd 0.04485f
C194 a_n1549_n3048# gnd 1.03771f
C195 a_n5289_n3048# gnd 0.0878f
C196 vco_delay_cell_3_1.out gnd 1.82942f
C197 vco_delay_cell_3_3.out gnd 1.73745f
C198 vco_delay_cell_3_6.out gnd 1.22196f
C199 a_13411_n1506# gnd 1.82571f
C200 a_9671_n1506# gnd 1.33051f
C201 a_5931_n1506# gnd 2.07513f
C202 a_2191_n1506# gnd 1.82693f
C203 a_n1549_n1506# gnd 1.55964f
C204 a_n5289_n1506# gnd 2.78653f
C205 a_14227_n714# gnd 0.59336f
C206 a_9671_n714# gnd 32.32628f
C207 a_5931_n714# gnd 1.31519f
C208 a_2191_n714# gnd 0.33768f
C209 a_n1549_n714# gnd 0.33768f
C210 vco_delay_cell_3_7.out gnd 3.61226f
C211 vco_delay_cell_3_8.out gnd 1.90062f
C212 a_14227_748# gnd 1.36569f
C213 a_9671_748# gnd 7.43113f
C214 a_5931_748# gnd 0.96796f
C215 a_2191_748# gnd 1.89108f
C216 a_n1549_748# gnd 1.79771f
.ends
* ==== END PEX substitutions ====
.end
