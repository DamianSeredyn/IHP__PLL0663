** sch_path: /foss/designs/IHP__PLL0663/PLL0663-main/schematic/xschem/vco/vco_core_0.sch
.subckt vco_core_0 vp gnd out in
*.PININFO in:I vp:B out:O gnd:B
MM1 pgt in gnd gnd sg13_lv_nmos w=0.8u l=0.14*4u ng=1
MM2 pgt pgt vp vp sg13_lv_pmos w=1.2u l=0.14*4u ng=1
x1 vp pgt out net1 in gnd vco_delay_cell_0
x2 vp pgt net1 2th in gnd vco_delay_cell_0
x3 vp pgt 2th 3th in gnd vco_delay_cell_0
x4 vp pgt 3th 4th in gnd vco_delay_cell_0
x7 vp pgt 4th out in gnd vco_delay_cell_0
.ends

* expanding   symbol:  /foss/designs/IHP__PLL0663/PLL0663-main/schematic/xschem/vco/vco_delay_cell_0.sym # of pins=6
** sym_path: /foss/designs/IHP__PLL0663/PLL0663-main/schematic/xschem/vco/vco_delay_cell_0.sym
** sch_path: /foss/designs/IHP__PLL0663/PLL0663-main/schematic/xschem/vco/vco_delay_cell_0.sch
.subckt vco_delay_cell_0 vp pgt in out ngt gnd
*.PININFO in:I out:O gnd:B vp:B pgt:B ngt:B
MM23 up pgt vp vp sg13_lv_pmos w=1.2u l=0.14*4u ng=1
MM1 out in up vp sg13_lv_pmos w=1.2u l=0.14*2u ng=1
MM2 out in dn gnd sg13_lv_nmos w=0.8u l=0.14*2u ng=1
MM26 dn ngt gnd gnd sg13_lv_nmos w=0.8u l=0.14*4u ng=1
.ends
