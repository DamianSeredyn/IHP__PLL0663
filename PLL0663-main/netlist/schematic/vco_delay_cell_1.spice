** sch_path: /foss/designs/IHP__PLL0663/PLL0663-main/schematic/xschem/vco/vco_delay_cell_1.sch
.subckt vco_delay_cell_1 vp pgt in out ngt gnd
*.PININFO in:I out:O gnd:B vp:B pgt:B ngt:B
MM23 up pgt vp vp sg13_lv_pmos w=1.2u l=0.35*4u ng=1
MM24 out in up vp sg13_lv_pmos w=1.2u l=0.35*2u ng=1
MM25 out in dn gnd sg13_lv_nmos w=0.8u l=0.35*2u ng=1
MM26 dn ngt gnd gnd sg13_lv_nmos w=0.8u l=0.35*4u ng=1
.ends
