** sch_path: /foss/designs/CHIP-PLL/schematics/vco/vco_tb/vco_dcin_tb.sch
**.subckt vco_dcin_tb
V1 in 0 {vin} ac 1
.save i(v1)
V2 vdd 0 {vdd}
x2 vdd 0 out in vco_core_0
V3 en5 0 1.2
*connector(1,1) ?1 en5
C3 out_pb 0 50f
x14 en5 nen5 vdd 0 inverter
*connector(1,1) ?1 nen5
x3 en5 en11 vdd 0 inverter
*connector(1,1) ?1 en11
x4 en11 nen11 vdd 0 inverter
*connector(1,1) ?1 nen11
*connector(1,1) ?1 nen5
*connector(1,1) ?1 en11
*connector(1,1) ?1 nen11
x1 vdd 0 out_pb out 0_buf
*connector(1,1) ?1 en5
**** begin user architecture code

.param temp=27
.param vdd=1.2
.param vin=0.4

.control

tran 40p 700n
write vco_tb.raw
set appendwrite
plot out
plot out_pb
.endc

 .lib cornerMOSlv.lib mos_tt

**** end user architecture code
**.ends

* expanding   symbol:  /foss/designs/CHIP-PLL/schematics/vco/vco_cell/vco_core_0.sym # of pins=4
** sym_path: /foss/designs/CHIP-PLL/schematics/vco/vco_cell/vco_core_0.sym
** sch_path: /foss/designs/CHIP-PLL/schematics/vco/vco_cell/vco_core_0.sch

* expanding   symbol:  /foss/designs/CHIP-PLL/schematics/divider/schematics/inverter.sym # of pins=4
** sym_path: /foss/designs/CHIP-PLL/schematics/divider/schematics/inverter.sym
** sch_path: /foss/designs/CHIP-PLL/schematics/divider/schematics/inverter.sch
.subckt inverter IN OUT VP GND
*.ipin IN
*.iopin VP
*.opin OUT
*.iopin GND
XM1 OUT IN GND GND sg13_lv_nmos w=0.15u l=0.13u ng=1 m=1 mm_ok=1
XM2 OUT IN VP VP sg13_lv_pmos w=0.15u l=0.13u ng=1 m=1 mm_ok=1
.ends

* expanding   symbol:  /foss/designs/CHIP-PLL/schematics/vco/vco_cell/0_buf.sym # of pins=4
** sym_path: /foss/designs/CHIP-PLL/schematics/vco/vco_cell/0_buf.sym
** sch_path: /foss/designs/CHIP-PLL/schematics/vco/vco_cell/0_buf.sch
.subckt 0_buf vp gnd out in
*.ipin in
*.opin out
*.iopin vp
*.iopin gnd
XM9 3th 2th vp vp sg13_lv_pmos w=2.5u l=0.13u ng=1 m=1 mm_ok=1
XM10 3th 2th gnd gnd sg13_lv_nmos w=2.5u l=0.13u ng=1 m=1 mm_ok=1
XM11 2th 1th vp vp sg13_lv_pmos w=2.4u l=0.13u ng=1 m=1 mm_ok=1
XM12 2th 1th gnd gnd sg13_lv_nmos w=1.2u l=0.13u ng=1 m=1 mm_ok=1
XM1 4th 3th vp vp sg13_lv_pmos w=5u l=0.13u ng=1 m=1 mm_ok=1
XM2 4th 3th gnd gnd sg13_lv_nmos w=5u l=0.13u ng=1 m=1 mm_ok=1
XM3 5th 4th vp vp sg13_lv_pmos w=10u l=0.13u ng=1 m=1 mm_ok=1
XM4 5th 4th gnd gnd sg13_lv_nmos w=10u l=0.13u ng=1 m=1 mm_ok=1
XM5 out 5th vp vp sg13_lv_pmos w=10u l=0.13u ng=1 m=2 mm_ok=1
XM6 out 5th gnd gnd sg13_lv_nmos w=10u l=0.13u ng=1 m=2 mm_ok=1
XM7 1th in gnd gnd sg13_lv_nmos w=0.8u l=0.13u ng=1 m=1 mm_ok=1
XM8 1th in vp vp sg13_lv_pmos w=1.5u l=0.13u ng=1 m=1 mm_ok=1
.ends

* expanding   symbol:  /foss/designs/CHIP-PLL/schematics/vco/vco_cell/vco_delay_cell_0.sym # of pins=6
** sym_path: /foss/designs/CHIP-PLL/schematics/vco/vco_cell/vco_delay_cell_0.sym
** sch_path: /foss/designs/CHIP-PLL/schematics/vco/vco_cell/vco_delay_cell_0.sch
.subckt vco_delay_cell_0 vp pgt in out ngt gnd
*.ipin in
*.opin out
*.iopin gnd
*.iopin vp
*.iopin pgt
*.iopin ngt
XM23 up pgt vp vp sg13_lv_pmos w=1.2u l=0.14*4u ng=1 m=1 mm_ok=1
XM1 out in up vp sg13_lv_pmos w=1.2u l=0.14*2u ng=1 m=1 mm_ok=1
XM2 out in dn gnd sg13_lv_nmos w=0.8u l=0.14*2u ng=1 m=1 mm_ok=1
XM26 dn ngt gnd gnd sg13_lv_nmos w=0.8u l=0.14*4u ng=1 m=1 mm_ok=1
.ends

* ==== BEGIN PEX substitutions (generated by -ext) ====
* ---- PEX adapter dla vco_core_0 ----
*   porty schematu (zachowane): vp gnd out in
*   porty ekstrakcji (xpex):    out in vp gnd
*   zwarcia (brak w ext):       [] -> {'v2i_vp': 'vp'}
.subckt vco_core_0 vp gnd out in
xpex out in vp gnd vco_core_0__pex
.ends
* PEX produced on Mon Nov  9 02:16:28 PM CET 2026 using /foss/tools/sak/sak-pex.sh with m=2 and s=1
* NGSPICE file created from vco_core_0.ext - technology: ihp-sg13cmos5l

.subckt vco_core_0__pex out in vp gnd
X0 vco_delay_cell_0_1.pgt vco_delay_cell_0_1.pgt vp vp sg13_lv_pmos ad=0.114p pd=0.98u as=0.204p ps=1.88u w=0.6u l=0.56u
X1 a_938_n478# out vco_delay_cell_0_4.in gnd sg13_lv_nmos ad=0.136p pd=1.48u as=76f ps=0.78u w=0.4u l=0.28u
X2 a_292_1054# vco_delay_cell_0_1.pgt vp vp sg13_lv_pmos ad=0.114p pd=0.98u as=0.204p ps=1.88u w=0.6u l=0.56u
X3 a_904_626# in gnd gnd sg13_lv_nmos ad=76f pd=0.78u as=0.136p ps=1.48u w=0.4u l=0.56u
X4 a_n354_n946# vco_delay_cell_0_1.pgt vp vp sg13_lv_pmos ad=0.114p pd=0.98u as=0.204p ps=1.88u w=0.6u l=0.56u
X5 vp vco_delay_cell_0_1.pgt a_904_1054# vp sg13_lv_pmos ad=0.204p pd=1.88u as=0.114p ps=0.98u w=0.6u l=0.56u
X6 a_938_n478# in gnd gnd sg13_lv_nmos ad=76f pd=0.78u as=0.136p ps=1.48u w=0.4u l=0.56u
X7 a_n354_n478# vco_delay_cell_0_3.in vco_delay_cell_0_1.in gnd sg13_lv_nmos ad=0.136p pd=1.48u as=76f ps=0.78u w=0.4u l=0.28u
X8 a_258_n478# vco_delay_cell_0_4.in vco_delay_cell_0_3.in gnd sg13_lv_nmos ad=0.136p pd=1.48u as=76f ps=0.78u w=0.4u l=0.28u
X9 vco_delay_cell_0_1.in vco_delay_cell_0_3.in a_n354_n946# vp sg13_lv_pmos ad=0.114p pd=0.98u as=0.204p ps=1.88u w=0.6u l=0.28u
X10 a_258_n478# in gnd gnd sg13_lv_nmos ad=76f pd=0.78u as=0.136p ps=1.48u w=0.4u l=0.56u
X11 a_292_1054# vco_delay_cell_0_1.in vco_delay_cell_0_1.out vp sg13_lv_pmos ad=0.204p pd=1.88u as=0.114p ps=0.98u w=0.6u l=0.28u
X12 a_292_626# vco_delay_cell_0_1.in vco_delay_cell_0_1.out gnd sg13_lv_nmos ad=0.136p pd=1.48u as=76f ps=0.78u w=0.4u l=0.28u
X13 a_n354_n478# in gnd gnd sg13_lv_nmos ad=76f pd=0.78u as=0.136p ps=1.48u w=0.4u l=0.56u
X14 out vco_delay_cell_0_1.out a_904_626# gnd sg13_lv_nmos ad=76f pd=0.78u as=0.136p ps=1.48u w=0.4u l=0.28u
X15 vp vco_delay_cell_0_1.pgt a_938_n946# vp sg13_lv_pmos ad=0.204p pd=1.88u as=0.114p ps=0.98u w=0.6u l=0.56u
X16 gnd in a_938_n478# gnd sg13_lv_nmos ad=0.136p pd=1.48u as=76f ps=0.78u w=0.4u l=0.56u
X17 vco_delay_cell_0_4.in out a_938_n946# vp sg13_lv_pmos ad=0.114p pd=0.98u as=0.204p ps=1.88u w=0.6u l=0.28u
X18 vp vco_delay_cell_0_1.pgt a_n354_n946# vp sg13_lv_pmos ad=0.204p pd=1.88u as=0.114p ps=0.98u w=0.6u l=0.56u
X19 gnd in a_904_626# gnd sg13_lv_nmos ad=0.136p pd=1.48u as=76f ps=0.78u w=0.4u l=0.56u
X20 vco_delay_cell_0_1.in vco_delay_cell_0_3.in a_n354_n478# gnd sg13_lv_nmos ad=76f pd=0.78u as=0.136p ps=1.48u w=0.4u l=0.28u
X21 gnd in vco_delay_cell_0_1.pgt gnd sg13_lv_nmos ad=0.136p pd=1.48u as=76f ps=0.78u w=0.4u l=0.56u
X22 gnd in a_258_n478# gnd sg13_lv_nmos ad=0.136p pd=1.48u as=76f ps=0.78u w=0.4u l=0.56u
X23 vco_delay_cell_0_3.in vco_delay_cell_0_4.in a_258_n946# vp sg13_lv_pmos ad=0.114p pd=0.98u as=0.204p ps=1.88u w=0.6u l=0.28u
X24 out vco_delay_cell_0_1.out a_904_1054# vp sg13_lv_pmos ad=0.114p pd=0.98u as=0.204p ps=1.88u w=0.6u l=0.28u
X25 a_938_n946# vco_delay_cell_0_1.pgt vp vp sg13_lv_pmos ad=0.114p pd=0.98u as=0.204p ps=1.88u w=0.6u l=0.56u
X26 vp vco_delay_cell_0_1.pgt a_292_1054# vp sg13_lv_pmos ad=0.204p pd=1.88u as=0.114p ps=0.98u w=0.6u l=0.56u
X27 a_904_1054# vco_delay_cell_0_1.out out vp sg13_lv_pmos ad=0.204p pd=1.88u as=0.114p ps=0.98u w=0.6u l=0.28u
X28 vp vco_delay_cell_0_1.pgt a_258_n946# vp sg13_lv_pmos ad=0.204p pd=1.88u as=0.114p ps=0.98u w=0.6u l=0.56u
X29 vp vco_delay_cell_0_1.pgt vco_delay_cell_0_1.pgt vp sg13_lv_pmos ad=0.204p pd=1.88u as=0.114p ps=0.98u w=0.6u l=0.56u
X30 vco_delay_cell_0_4.in out a_938_n478# gnd sg13_lv_nmos ad=76f pd=0.78u as=0.136p ps=1.48u w=0.4u l=0.28u
X31 a_258_n946# vco_delay_cell_0_1.pgt vp vp sg13_lv_pmos ad=0.114p pd=0.98u as=0.204p ps=1.88u w=0.6u l=0.56u
X32 a_292_626# in gnd gnd sg13_lv_nmos ad=76f pd=0.78u as=0.136p ps=1.48u w=0.4u l=0.56u
X33 a_938_n946# out vco_delay_cell_0_4.in vp sg13_lv_pmos ad=0.204p pd=1.88u as=0.114p ps=0.98u w=0.6u l=0.28u
X34 gnd in a_292_626# gnd sg13_lv_nmos ad=0.136p pd=1.48u as=76f ps=0.78u w=0.4u l=0.56u
X35 a_904_1054# vco_delay_cell_0_1.pgt vp vp sg13_lv_pmos ad=0.114p pd=0.98u as=0.204p ps=1.88u w=0.6u l=0.56u
X36 vco_delay_cell_0_1.pgt in gnd gnd sg13_lv_nmos ad=76f pd=0.78u as=0.136p ps=1.48u w=0.4u l=0.56u
X37 vco_delay_cell_0_3.in vco_delay_cell_0_4.in a_258_n478# gnd sg13_lv_nmos ad=76f pd=0.78u as=0.136p ps=1.48u w=0.4u l=0.28u
X38 a_n354_n946# vco_delay_cell_0_3.in vco_delay_cell_0_1.in vp sg13_lv_pmos ad=0.204p pd=1.88u as=0.114p ps=0.98u w=0.6u l=0.28u
X39 vco_delay_cell_0_1.out vco_delay_cell_0_1.in a_292_1054# vp sg13_lv_pmos ad=0.114p pd=0.98u as=0.204p ps=1.88u w=0.6u l=0.28u
X40 a_904_626# vco_delay_cell_0_1.out out gnd sg13_lv_nmos ad=0.136p pd=1.48u as=76f ps=0.78u w=0.4u l=0.28u
X41 a_258_n946# vco_delay_cell_0_4.in vco_delay_cell_0_3.in vp sg13_lv_pmos ad=0.204p pd=1.88u as=0.114p ps=0.98u w=0.6u l=0.28u
X42 gnd in a_n354_n478# gnd sg13_lv_nmos ad=0.136p pd=1.48u as=76f ps=0.78u w=0.4u l=0.56u
X43 vco_delay_cell_0_1.out vco_delay_cell_0_1.in a_292_626# gnd sg13_lv_nmos ad=76f pd=0.78u as=0.136p ps=1.48u w=0.4u l=0.28u
C0 vp vco_delay_cell_0_4.in 0.4994f
C1 vco_delay_cell_0_1.out a_904_626# 0.06929f
C2 a_n354_n946# a_258_n946# 0.01898f
C3 vco_delay_cell_0_1.out vco_delay_cell_0_1.in 0.25002f
C4 in a_904_626# 0.12562f
C5 vco_delay_cell_0_1.pgt out 0.05971f
C6 vco_delay_cell_0_1.in a_292_1054# 0.07831f
C7 in vco_delay_cell_0_1.in 0.16046f
C8 vco_delay_cell_0_1.pgt a_292_626# 0.01152f
C9 vco_delay_cell_0_1.pgt a_904_1054# 0.11445f
C10 a_258_n478# a_938_n478# 0.01446f
C11 vp out 0.47305f
C12 in vco_delay_cell_0_4.in 0.08487f
C13 vp a_292_626# 0.02255f
C14 vp a_904_1054# 0.15551f
C15 a_n354_n478# a_258_n478# 0.01752f
C16 a_938_n946# a_258_n946# 0.01578f
C17 vco_delay_cell_0_1.out out 0.28197f
C18 vco_delay_cell_0_4.in a_938_n946# 0.12322f
C19 vco_delay_cell_0_3.in a_258_n478# 0.11652f
C20 vp a_258_n478# 0.02255f
C21 vco_delay_cell_0_4.in a_258_n946# 0.08084f
C22 vco_delay_cell_0_1.out a_292_626# 0.11652f
C23 vco_delay_cell_0_1.out a_904_1054# 0.08176f
C24 a_n354_n478# vco_delay_cell_0_3.in 0.06929f
C25 in out 0.16173f
C26 vco_delay_cell_0_1.pgt vco_delay_cell_0_3.in 0.07815f
C27 a_904_626# out 0.12443f
C28 vco_delay_cell_0_1.pgt vp 5.00974f
C29 a_904_1054# a_292_1054# 0.01898f
C30 in a_292_626# 0.12828f
C31 a_904_626# a_292_626# 0.01752f
C32 vco_delay_cell_0_1.pgt a_n354_n946# 0.12423f
C33 vp vco_delay_cell_0_3.in 0.47856f
C34 out a_938_n946# 0.081f
C35 vco_delay_cell_0_1.in a_292_626# 0.06725f
C36 a_n354_n946# vco_delay_cell_0_3.in 0.08176f
C37 in a_938_n478# 0.12756f
C38 vp a_n354_n946# 0.15556f
C39 vco_delay_cell_0_4.in out 0.25282f
C40 vco_delay_cell_0_1.pgt vco_delay_cell_0_1.out 0.07413f
C41 in a_258_n478# 0.12786f
C42 in a_n354_n478# 0.12518f
C43 vco_delay_cell_0_1.pgt a_292_1054# 0.12984f
C44 in vco_delay_cell_0_1.pgt 0.07287f
C45 vco_delay_cell_0_1.out vp 0.48527f
C46 a_n354_n478# vco_delay_cell_0_1.in 0.12459f
C47 vco_delay_cell_0_4.in a_938_n478# 0.1165f
C48 vco_delay_cell_0_1.pgt vco_delay_cell_0_1.in 0.86305f
C49 in vco_delay_cell_0_3.in 0.08169f
C50 vp a_292_1054# 0.1849f
C51 vco_delay_cell_0_4.in a_258_n478# 0.06851f
C52 in vp 0.38728f
C53 vco_delay_cell_0_1.pgt a_938_n946# 0.11593f
C54 vco_delay_cell_0_1.in vco_delay_cell_0_3.in 0.28038f
C55 vco_delay_cell_0_1.pgt a_258_n946# 0.1168f
C56 vp vco_delay_cell_0_1.in 0.63081f
C57 a_904_1054# out 0.12317f
C58 vco_delay_cell_0_1.pgt vco_delay_cell_0_4.in 0.07604f
C59 a_n354_n946# vco_delay_cell_0_1.in 0.12373f
C60 vp a_938_n946# 0.15984f
C61 vco_delay_cell_0_3.in a_258_n946# 0.12324f
C62 vco_delay_cell_0_4.in vco_delay_cell_0_3.in 0.27785f
C63 vco_delay_cell_0_1.out a_292_1054# 0.12324f
C64 vp a_258_n946# 0.18178f
C65 out a_938_n478# 0.07779f
C66 in vco_delay_cell_0_1.out 0.08247f
C67 out gnd 0.0168f
C68 vp gnd 1.38104f
C69 a_938_n946# gnd 0.29638f
C70 a_258_n946# gnd 0.13569f
C71 a_n354_n946# gnd 0.33007f
C72 a_938_n478# gnd 0.63247f
C73 a_258_n478# gnd 0.59977f
C74 a_n354_n478# gnd 0.3742f
C75 a_904_626# gnd 2.76438f
C76 a_292_626# gnd 0.1352f
C77 a_904_1054# gnd 0.02895f
C78 a_292_1054# gnd 0.63315f
.ends
* ==== END PEX substitutions ====
.end
